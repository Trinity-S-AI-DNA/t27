SAR_logic with one dff's Set and Reset swapped, transistor level, PSP103 tt at 50 C: the negative control of sar_logic.t27
* specs/analog/decks/sar_logic_swap.cir -- reference data for specs/analog/sar_logic.t27 (M4d, #10754, epic #10486). The same bench as sar_logic_ref.cir
* (golden SAR deck, uberWAVE wp2-parser/golden/top.spice, GPL-2.0, fetched at run time; ideal clks and eleven Valid pulses; the sequencer's own CK edges),
* with ONE change: the subcircuit sar_swap below is SAR_logic written out again, eleven dff on the same nets, except that the fifth dff (x5, the one that
* drives CK7) has its Reset and Set pins exchanged: Reset = Set (a constant 0) and Set = clks. While clks is high that dff is SET instead of reset, and it is
* never reset. The dff, tgate, nor and inverter are the golden deck's own.
* Paths are NOT in this file: IHP_PDK, IHP_OSDI and SAR_GOLDEN_SUBCKTS from the environment (see sar_gate_arcs.cir).
* Run: IHP_PDK=<checkout> IHP_OSDI=<osdi dir> SAR_GOLDEN_SUBCKTS=<file> ngspice -b sar_logic_swap.cir   (ngspice-47)
* It prints <name> = <seconds>: tck7r1 / tck7r2 (CK7 rises, 1st and 2nd), tck7f1 (CK7 falls), tck6r1 / tck6r2 / tck6f1 (CK6), tck11 (CK11 rises).
* What it shows, 50 % points: CK7 is high from the reset (rise 1, 0.5 ns), falls at the first Valid edge (80.1 ns -> 80.6 ns) because the stage takes its D = 0, and rises
* again at its own turn (the fifth edge); CK6, whose D is CK7, rises at the FIRST edge (it sees D = 1), falls at the second and rises at its own turn (the sixth).
.lib $IHP_PDK/ihp-sg13g2/libs.tech/ngspice/models/cornerMOSlv.lib mos_tt
.include $SAR_GOLDEN_SUBCKTS
.subckt sar_swap CK3 CK11 CK7 CK2 CK6 CK10 CK1 CK9 CK5 CK8 CK4 VDD VSS D Valid Set clks
x1 VDD VSS CK11 Valid net1 D clks Set dff
x2 VDD VSS CK10 Valid net2 CK11 clks Set dff
x3 VDD VSS CK9 Valid net3 CK10 clks Set dff
x4 VDD VSS CK8 Valid net4 CK9 clks Set dff
x5 VDD VSS CK7 Valid net5 CK8 Set clks dff
x6 VDD VSS CK6 Valid net6 CK7 clks Set dff
x7 VDD VSS CK5 Valid net7 CK6 clks Set dff
x8 VDD VSS CK4 Valid net8 CK5 clks Set dff
x9 VDD VSS CK3 Valid net9 CK4 clks Set dff
x10 VDD VSS CK2 Valid net10 CK3 clks Set dff
x11 VDD VSS CK1 Valid net11 CK2 clks Set dff
.ends
VDD vdd 0 1.5
Vclks clks 0 PULSE(0 1.5 0n 1n 1n 30n 1u)
Vvalid valid 0 PULSE(0 1.5 80n 0.2n 0.2n 20n 40n)
Vd d 0 1.5
Vset set 0 0
Va a 0 0
Vb b 0 0
Vc c 0 0
x7 ck3 ck11 ck7 ck2 ck6 ck10 ck1 ck9 ck5 ck8 ck4 vdd 0 d valid set clks sar_swap
x4 vdd clkc 0 clks valid ck1 a b c clock_gen
Cvalid valid 0 12f
Cck1 ck1 0 4f
Cclkc clkc 0 8f
.temp 50
.options reltol=1e-3
.tran 5p 520n 0 50p
.control
pre_osdi $IHP_OSDI/psp103.osdi
pre_osdi $IHP_OSDI/psp103_nqs.osdi
set numdgt=7
run
meas tran tck11 when v(ck11)=0.75 rise=LAST
meas tran tck7r1 when v(ck7)=0.75 rise=1
meas tran tck7r2 when v(ck7)=0.75 rise=2
meas tran tck7f1 when v(ck7)=0.75 fall=1
meas tran tck6r1 when v(ck6)=0.75 rise=1
meas tran tck6r2 when v(ck6)=0.75 rise=2
meas tran tck6f1 when v(ck6)=0.75 fall=1
.endc
.end
