The golden SAR ADC's sine run at the comparator's clock edge of six decisions: the plates' own waves, the bottom plates' nodes and the charge the pair's gates take (M4e-kick, #10942)
* specs/analog/decks/sar_kick_plates.cir -- sar_kick_late.cir (the golden SAR ADC deck, wp2-parser/golden/top.spice, GPL-2.0: fetched at run time, never vendored; the subcircuits come from the
* run-time file SAR_GOLDEN_SUBCKTS, made as in sar_off_base.cir) with two zero-volt meters added and a wider readout; the circuit is the golden one. VMP (VMN) sits in series between the plate VDP
* (VDN) and the gate of the comparator's input pair: its current is the current the 36 devices' gates take from the plate, and its integral from the 0.1 V crossing of clkc is the charge pulse
* qpw (qnw, in coulomb) that sar_kick_net.t27 derives from the charge tables. The readout is the six windows of sar_kick_late.cir (the clkc rises 1, 10, 11, 12, 21, 22: decisions 0, 9, 10 of the
* first conversion and of the second; 67 samples 0.1 ns apart from 1.5 ns before the 0.1 V crossing) with, besides the tail node net1 and the drain ap, the plates vdp and vdn and the two charges, the
* voltage of each bottom-plate node of the DAC: bit_1 .. bit_10 (the P half's plates, behind DAC_control's inverter or its tgate to VCM) and bit_1_n .. bit_10_n (the N half's, behind
* neg_bottom_plate_logic): what each plate does through the kick, and what the drivers hold it with. Bit_k belongs to the plate of k units (1, 2, 4, 8, 16 on net1 for k = 1 .. 5, on the top plate for
* k = 6 .. 10).
* Paths are NOT in this file: IHP_PDK (the IHP-Open-PDK checkout, commit 21133f21), IHP_OSDI (the directory with the compiled psp103.osdi, psp103_nqs.osdi, r3_cmc.osdi, mosvar.osdi,
* cap_cmomi.osdi, cap_cmomf.osdi), SAR_GOLDEN_SUBCKTS, and sar_dmv, sar_amp, sar_tstop (the input as in sar_off_base.cir: sar_dmv the DC differential input in mV, sar_amp the sine's amplitude, 0 for a
* DC input, sar_tstop the run's end), in the environment. Run the sine: sar_dmv=0 sar_amp=0.6 sar_tstop=1.1u IHP_PDK=<checkout> IHP_OSDI=<osdi dir> SAR_GOLDEN_SUBCKTS=<file> ngspice -b
* sar_kick_plates.cir   (ngspice-47, the transient of 1.1 us at 50 ps is the long part of it: minutes on two cores); a DC conversion: sar_dmv=-196.21 sar_amp=0 sar_tstop=470n (about a minute and a half).
* The windows are then the clkc rises 1, 10, 11 (sar_amp 0) or 1, 10, 11, 12, 21, 22 (the sine). It prints, between BEGIN plates and END plates, per window: WINDOW rr, the crossing times tcb and
* tcc, j0, the plates' voltages at the crossing (vpt, vnt), the latch's two internal outputs dd = v(x3.dp) and de = v(x3.dn) 4.8 ns after the crossing (the readout of sar_kick_late_aperture.cir:
* with the plates as they are, dd - de is the decision's margin, zero where the decision flips; its slope in the input is 25 mV per mV there) and the comparator's outputs vop, von 12 ns after it, then
* the table n1w apw vpw vnw qpw qnw and, for each bottom plate node, NODE name and its 67 samples.
.param dmv=0
.param amp=0.6
.lib $IHP_PDK/ihp-sg13g2/libs.tech/ngspice/models/cornerMOSlv.lib mos_tt
.lib $IHP_PDK/ihp-sg13g2/libs.tech/ngspice/models/cornerCAP.lib cap_typ
.include $SAR_GOLDEN_SUBCKTS
* supplies, trim code A B C = 0 0 0, the common mode, the sampling clock and the differential sine input
VDD4 vdda 0 1.5
VDD6 vdd 0 1.5
VDD7 vcm 0 0.75
V2 c 0 0
V5 b 0 0
V6 a 0 0
VDD1 vss 0 0
VCMS net2 0 0.75
VCLKS clks 0 PULSE(0 1.5 0n 2n 2n 80n 500n)
VSP net2 vinp sin({-dmv*0.5e-3} {amp} 62.5k)
VSN vinn net2 sin({-dmv*0.5e-3} {amp} 62.5k)
* the two tracking switches, the comparator, the SAR logic and the clock generator
x1 vdda 0 vinn vdn clks tracking_switch
x2 vdda 0 vinp vdp clks tracking_switch
x3 vocp vocn valid vdpc vdnc clkc vdd 0 dynamic_comparator_top
* the two additions: zero-volt meters in series between each plate and its gate (the current flows from the plate into the gate)
VMP vdp vdpc 0
VMN vdn vdnc 0
x7 ck3 ck11 ck7 ck2 ck6 ck10 ck1 ck9 ck5 ck8 ck4 vdd 0 vdd valid 0 clks SAR_logic
x4 vdd clkc 0 clks valid ck1 a b c clock_gen
* the 4 fF loads the golden top hangs on the top plates and on the control nets
C3 vdp 0 4f
C4 vdn 0 4f
C5 vdp 0 4f
C6 vdn 0 4f
C7 vinp 0 4f
C8 vinn 0 4f
C9 clkc 0 4f
C10 vocp 0 4f
C11 valid 0 4f
C12 vocn 0 4f
C13 clkc 0 4f
C14 clks 0 4f
C15 valid 0 4f
C16 ck1 0 4f
C17 a 0 4f
C18 b 0 4f
C19 c 0 4f
C20 clks 0 4f
C21 valid 0 4f
C22 vdd 0 4f
* the bottom-plate drivers (every stage decides on vocn), then the negated copy of each bit for the N half
x5 vdd bit_10 vocn 0 ck11 vcm out_11 0 0 clks bit_9 vocn ck10 out_10 bit_8 vocn ck9 out_9 bit_7 vocn ck8 out_8 bit_6 vocn
+ ck7 out_7 bit_5 vocn ck6 out_6 bit_4 vocn ck5 out_5 bit_3 vocn ck4 out_4 bit_2 vocn ck3 out_3 bit_1 vocn ck2 out_2 bit_0 vocn ck1
+ out_1 DAC_control_top
x6 vdd vss ck11 bit_10 bit_10_n neg_bottom_plate_logic
x8 vdd vss ck6 bit_5 bit_5_n neg_bottom_plate_logic
x9 vdd vss ck10 bit_9 bit_9_n neg_bottom_plate_logic
x10 vdd vss ck5 bit_4 bit_4_n neg_bottom_plate_logic
x11 vdd vss ck9 bit_8 bit_8_n neg_bottom_plate_logic
x12 vdd vss ck4 bit_3 bit_3_n neg_bottom_plate_logic
x13 vdd vss ck8 bit_7 bit_7_n neg_bottom_plate_logic
x14 vdd vss ck3 bit_2 bit_2_n neg_bottom_plate_logic
x15 vdd vss ck7 bit_6 bit_6_n neg_bottom_plate_logic
x16 vdd vss ck2 bit_1 bit_1_n neg_bottom_plate_logic
* the deck's own output adder: V(out) = 1.5 V code / 2048 with the bits at 0 / 1.5 V
E1 out net12 out_11 0 0.5
E2 net12 net11 out_10 0 0.25
E3 net11 net10 out_9 0 0.125
E4 net10 net9 out_8 0 0.0625
E5 net9 net8 out_7 0 0.03125
E6 net8 net7 out_6 0 0.015625
E7 net7 net6 out_5 0 0.0078125
E8 net6 net5 out_4 0 0.00390625
E9 net5 net4 out_3 0 0.001953125
E10 net4 net3 out_2 0 0.0009765625
E11 net3 0 out_1 0 0.00048828125
* the two capacitive DAC halves: the N half on VDN with the negated bits, the P half on VDP
x17 vdn bit_3_n bit_8_n bit_5_n bit_6_n bit_7_n bit_4_n bit_9_n bit_10_n bit_2_n bit_1_n Diff_cap_DAC
x18 vdp bit_3 bit_8 bit_5 bit_6 bit_7 bit_4 bit_9 bit_10 bit_2 bit_1 Diff_cap_DAC
.ic v(x1.net1)=0
.ic v(x1.net2)=0
.nodeset v(x1.net2)=0
.ic v(x1.net3)=0
.ic v(x2.net1)=0
.ic v(x2.net2)=0
.ic v(x2.net3)=0
.ic v(x17.net1)=0
.ic v(x18.net1)=0
.ic v(vdp)=0
.ic v(vdn)=0
.options temp=50
.options klu
.save v(vdp) v(vdn) v(clkc) v(x3.x1.ap) v(x3.x1.net1) v(x3.dp) v(x3.dn) v(vocp) v(vocn) i(vmp) i(vmn)
.save v(bit_1) v(bit_2) v(bit_3) v(bit_4) v(bit_5) v(bit_6) v(bit_7) v(bit_8) v(bit_9) v(bit_10)
.save v(bit_1_n) v(bit_2_n) v(bit_3_n) v(bit_4_n) v(bit_5_n) v(bit_6_n) v(bit_7_n) v(bit_8_n) v(bit_9_n) v(bit_10_n)
.control
pre_osdi $IHP_OSDI/psp103.osdi
pre_osdi $IHP_OSDI/psp103_nqs.osdi
pre_osdi $IHP_OSDI/r3_cmc.osdi
pre_osdi $IHP_OSDI/mosvar.osdi
pre_osdi $IHP_OSDI/cap_cmomi.osdi
pre_osdi $IHP_OSDI/cap_cmomf.osdi
set num_threads=2
alterparam dmv = $sar_dmv
alterparam amp = $sar_amp
reset
tran 0.05n $sar_tstop
linearize v(clkc) v(x3.x1.net1) v(x3.x1.ap) v(vdp) v(vdn) v(x3.dp) v(x3.dn) v(vocp) v(vocn) i(vmp) i(vmn) v(bit_1) v(bit_2) v(bit_3) v(bit_4) v(bit_5) v(bit_6) v(bit_7) v(bit_8) v(bit_9) v(bit_10) v(bit_1_n) v(bit_2_n) v(bit_3_n) v(bit_4_n) v(bit_5_n) v(bit_6_n) v(bit_7_n) v(bit_8_n) v(bit_9_n) v(bit_10_n)
let qp = integ(i(vmp))
let qn = integ(i(vmn))
set numdgt=8
set noprintscale
echo BEGIN plates
let rl = unitvec(6)
let rl[0] = 1
let rl[1] = 10
let rl[2] = 11
let rl[3] = 12
let rl[4] = 21
let rl[5] = 22
let nrise = 6
if $sar_amp = 0
  let nrise = 3
end
let ii = 0
while ii < nrise
  let rr = rl[ii]
  meas tran tcb when v(clkc)=0.1 rise=$&rr
  meas tran tcc when v(clkc)=0.75 rise=$&rr
  meas tran vpt find v(vdp) when v(clkc)=0.1 rise=$&rr
  meas tran vnt find v(vdn) when v(clkc)=0.1 rise=$&rr
  let tread = tcb + 4.8e-9
  meas tran dd find v(x3.dp) at=$&tread
  meas tran de find v(x3.dn) at=$&tread
  let tfin = tcb + 12e-9
  meas tran vop find v(vocp) at=$&tfin
  meas tran von find v(vocn) at=$&tfin
  let j0 = floor(tcb / 5e-11) - 30
  let n1w = unitvec(67)
  let apw = unitvec(67)
  let vpw = unitvec(67)
  let vnw = unitvec(67)
  let qpw = unitvec(67)
  let qnw = unitvec(67)
  let k = 0
  while k < 67
    let j = j0 + 2*k
    let n1w[k] = v(x3.x1.net1)[j]
    let apw[k] = v(x3.x1.ap)[j]
    let vpw[k] = v(vdp)[j]
    let vnw[k] = v(vdn)[j]
    let qpw[k] = qp[j] - qp[j0]
    let qnw[k] = qn[j] - qn[j0]
    let k = k + 1
  end
  echo WINDOW $&rr
  print tcb tcc j0 vpt vnt dd de vop von
  print n1w apw vpw vnw
  print qpw qnw
  foreach nm 1 2 3 4 5 6 7 8 9 10 1_n 2_n 3_n 4_n 5_n 6_n 7_n 8_n 9_n 10_n
    let bw = unitvec(67)
    let k = 0
    while k < 67
      let j = j0 + 2*k
      let bw[k] = v(bit_$nm)[j]
      let k = k + 1
    end
    echo NODE bit_$nm
    print bw
  end
  let ii = ii + 1
end
echo END plates
.endc
.end
