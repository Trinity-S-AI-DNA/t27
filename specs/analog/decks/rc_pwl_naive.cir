M0 RC low-pass, backward Euler with a PWL source: the negative control of rc_fixed.cir
* specs/analog/decks/rc_pwl_naive.cir -- test data for specs/analog/bench.t27 (#10505). A plain netlist, no .control block.
* The same circuit, integration (gear, maxord 1 = backward Euler) and trtol as rc_fixed.cir, but the source is the
* natural PWL. The corners at 5000 ns and 5050 ns are breakpoints: ngspice reaches them exactly and restarts its step
* ramp after each (steps of a fraction of the interval that double up to tmax), and it also opens the run with such a
* ramp. So the internal points are NOT the 50 ns grid and the result is backward Euler on a different, nonuniform
* grid: v(1) at 5000 ns differs from the backward Euler recurrence at the 1e-5 level, not at the 1e-15 level.
* Run: ngspice -b -r rc_pwl_naive.raw rc_pwl_naive.cir   (the raw file holds float64 values)
V1 in 0 PWL(0 1 5000n 1 5050n 0)
R1 in 1 1k
C1 1 0 1n IC=0
.options method=gear maxord=1 trtol=1e7
.tran 50n 10000n 0 50n uic
.end
