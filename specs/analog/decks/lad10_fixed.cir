10-node RC ladder (beyond the M1 cell), backward Euler on a fixed 50 ns grid
* specs/analog/decks/lad10_fixed.cir -- test data for specs/analog/bench.t27 (#10505). A plain netlist, no .control block.
* Circuit: R1..R10 = 1 kOhm in series from IN through nodes 1..10; C1..C10 = 1 nF from nodes 1..10 to ground; all
* capacitors start at 0 V. This is NOT a circuit of specs/analog/linear.t27 (its NMAX is 5): it is here so the ngspice
* wall time can be read against circuit size, and it has no board number.
* Run: 200 steps of 50 ns, IN = 1 V for the first 100 steps and 0 V for the next 100.
* The grid is made exact as in rc_fixed.cir: a B source declares no breakpoint, the circuit rests at 0 V while the source
* is 0, the source turns on at 425 ns (half a step from the nearest grid point) and turns off at 5425 ns, and from the
* first internal point after 425 ns every step is 50 ns. Step k (k = 0..199) ends at the k-th internal point after 425 ns.
* tstop = 425 ns + 201 steps. gear with maxord 1 is backward Euler; trtol = 1e7 stops the truncation test.
* Run: ngspice -b -r lad10_fixed.raw lad10_fixed.cir   (the raw file holds float64 values)
B1 in 0 V = u(time-425n) - u(time-5425n)
R1 in 1 1k
R2 1 2 1k
R3 2 3 1k
R4 3 4 1k
R5 4 5 1k
R6 5 6 1k
R7 6 7 1k
R8 7 8 1k
R9 8 9 1k
R10 9 10 1k
C1 1 0 1n IC=0
C2 2 0 1n IC=0
C3 3 0 1n IC=0
C4 4 0 1n IC=0
C5 5 0 1n IC=0
C6 6 0 1n IC=0
C7 7 0 1n IC=0
C8 8 0 1n IC=0
C9 9 0 1n IC=0
C10 10 0 1n IC=0
.options method=gear maxord=1 trtol=1e7
.tran 50n 10475n 0 50n uic
.end
