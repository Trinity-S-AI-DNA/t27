M5 RAW layout reference: an RC charge, first 100 ns, written by ngspice as ASCII and as binary
* specs/analog/decks/raw_ref.cir -- test data for specs/analog/raw_writer.t27 (#10909). It has a .control block because the
* point of the deck is ngspice's own `write`: raw_writer.t27 embeds the two files this deck writes (ASCII and binary) as
* the reference its output must equal byte for byte, apart from the Date line, which the writer takes as a parameter.
* Circuit: V1 = 1 V from IN to ground, R1 = 1 kOhm from IN to OUT, C1 = 1 nF from OUT to ground, OUT starts at 0 V.
* Run: ngspice -b raw_ref.cir   (from an empty directory; it writes raw_ref_ascii.raw and raw_ref_bin.raw there)
* The trace is 15 points of 4 variables (time, v(in), v(out), i(v1)): the first internal steps of the transient, which
* double from 10 ps, then the last point at 100 ns. The values are plain doubles; the binary file holds them exactly and
* the ASCII file holds each one rounded to 16 significant digits ("%.15e").
V1 in 0 1
R1 in out 1k
C1 out 0 1n IC=0
.control
tran 1u 100n 0 1u uic
set filetype=ascii
write raw_ref_ascii.raw in out v1#branch
set filetype=binary
write raw_ref_bin.raw in out v1#branch
.endc
.end
