The on-resistance of the golden tgate and inverter at the bottom plates' bias: the measurement behind the M4e-offset explanation (#10888)
* specs/analog/decks/sar_off_ron.cir -- how soft is a bottom plate's drive? The golden top level has two kinds of drive: DAC_control's inverter (and its tgate x2 to VCM while a bit is idle) on the
* P half, and neg_bottom_plate_logic's tgate x11 (idle) or inverter x12 plus tgate x15 (moved) on the N half, one transmission gate more. This deck measures, with the golden subcircuits tgate and
* inverter (from the run-time file SAR_GOLDEN_SUBCKTS, the IHP SG13G2 PSP103 model of IHP-Open-PDK 21133f21, mos_tt, 50 C), the DC resistance of
*   a tgate conducting at VCM (pmos gate 0 V, nmos gate 1.5 V, Vdd 1.5 V), 10 mV across it at 0.75 V: R = 10 mV / I   (rtg)
*   an inverter holding its output at a rail: the pmos W 3 um with its input at 0 V and the output 10 mV under Vdd (rinvp), the nmos W 1 um with its input at 1.5 V and the output 10 mV
*   over ground (rinvn): R = 10 mV / I
* Paths: IHP_PDK, IHP_OSDI, SAR_GOLDEN_SUBCKTS as in sar_off_base.cir. Run: ngspice -b sar_off_ron.cir (seconds); it prints rtg, rinvp, rinvn in ohms.
.lib $IHP_PDK/ihp-sg13g2/libs.tech/ngspice/models/cornerMOSlv.lib mos_tt
.include $SAR_GOLDEN_SUBCKTS
VDD vdd 0 1.5
VG0 g0 0 0
VG1 g1 0 1.5
VIN tin 0 0.76
VOUT tout 0 0.75
XT g0 g1 tin tout vdd 0 tgate
XIP g0 vdd 0 opn inverter
VOPN opn 0 1.49
XIN g1 vdd 0 onn inverter
VONN onn 0 0.01
.options temp=50
.control
pre_osdi $IHP_OSDI/psp103.osdi
pre_osdi $IHP_OSDI/psp103_nqs.osdi
op
let rtg = 0.01 / abs(i(vin))
let rinvp = 0.01 / abs(i(vopn))
let rinvn = 0.01 / abs(i(vonn))
print rtg
print rinvp
print rinvn
.endc
.end
