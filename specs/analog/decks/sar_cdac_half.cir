SAR ADC split capacitive DAC, one half (x18 of the golden deck), ideal capacitors, 1024 codes in one run
* specs/analog/decks/sar_cdac_half.cir -- test data for specs/analog/sar_cdac.t27 (#10540). A plain netlist, no .control block.
* Topology of Diff_cap_DAC (the golden SAR ADC deck, subckt Diff_cap_DAC, lines 529-591): 31 unit capacitors from net1 (node l) to the LSB plates
* p1..p5 (1, 2, 4, 8, 16 units), one unit between net1 and Vout (node m), 31 unit capacitors from Vout to the MSB plates p6..p10 (1, 2, 4, 8, 16).
* Unit = 100 fF, ideal. Plate p_j is Bit_j. The tracking switch is not modelled: Vout and net1 start at the sampled 0.75 V (.ic, and IC=0 on every
* capacitor because every plate rests at VCM = 0.75 V and the bridge is uncharged). From 10 ns, interval n (n = 0..1023, 10 ns each) puts plate j
* at VDD = 1.5 V when bit j-1 of n is 1 and at 0 V when it is 0: the code is n, and the plates go straight from code n-1 to code n. The network is
* algebraic (capacitors only), so the settled voltage of an interval does not depend on the time grid; a B source declares no breakpoint.
* Read the LAST printed point inside each interval. Run: ngspice -b sar_cdac_half.cir   (.print shows 7 digits; the spec's table was read with
* set numdgt=15 in a control block wrapped around this same netlist, so it holds the full float64 values).
C1_1 l p1 100f IC=0
C2_1 l p2 100f IC=0
C2_2 l p2 100f IC=0
C3_1 l p3 100f IC=0
C3_2 l p3 100f IC=0
C3_3 l p3 100f IC=0
C3_4 l p3 100f IC=0
C4_1 l p4 100f IC=0
C4_2 l p4 100f IC=0
C4_3 l p4 100f IC=0
C4_4 l p4 100f IC=0
C4_5 l p4 100f IC=0
C4_6 l p4 100f IC=0
C4_7 l p4 100f IC=0
C4_8 l p4 100f IC=0
C5_1 l p5 100f IC=0
C5_2 l p5 100f IC=0
C5_3 l p5 100f IC=0
C5_4 l p5 100f IC=0
C5_5 l p5 100f IC=0
C5_6 l p5 100f IC=0
C5_7 l p5 100f IC=0
C5_8 l p5 100f IC=0
C5_9 l p5 100f IC=0
C5_10 l p5 100f IC=0
C5_11 l p5 100f IC=0
C5_12 l p5 100f IC=0
C5_13 l p5 100f IC=0
C5_14 l p5 100f IC=0
C5_15 l p5 100f IC=0
C5_16 l p5 100f IC=0
C6_1 m p6 100f IC=0
C7_1 m p7 100f IC=0
C7_2 m p7 100f IC=0
C8_1 m p8 100f IC=0
C8_2 m p8 100f IC=0
C8_3 m p8 100f IC=0
C8_4 m p8 100f IC=0
C9_1 m p9 100f IC=0
C9_2 m p9 100f IC=0
C9_3 m p9 100f IC=0
C9_4 m p9 100f IC=0
C9_5 m p9 100f IC=0
C9_6 m p9 100f IC=0
C9_7 m p9 100f IC=0
C9_8 m p9 100f IC=0
C10_1 m p10 100f IC=0
C10_2 m p10 100f IC=0
C10_3 m p10 100f IC=0
C10_4 m p10 100f IC=0
C10_5 m p10 100f IC=0
C10_6 m p10 100f IC=0
C10_7 m p10 100f IC=0
C10_8 m p10 100f IC=0
C10_9 m p10 100f IC=0
C10_10 m p10 100f IC=0
C10_11 m p10 100f IC=0
C10_12 m p10 100f IC=0
C10_13 m p10 100f IC=0
C10_14 m p10 100f IC=0
C10_15 m p10 100f IC=0
C10_16 m p10 100f IC=0
Cbr l m 100f IC=0
B1 p1 0 V = 0.75 + 0.75*u(time-10n)*(2*(floor(floor((time-10n)/10n)/1)-2*floor(floor((time-10n)/10n)/2))-1)
B2 p2 0 V = 0.75 + 0.75*u(time-10n)*(2*(floor(floor((time-10n)/10n)/2)-2*floor(floor((time-10n)/10n)/4))-1)
B3 p3 0 V = 0.75 + 0.75*u(time-10n)*(2*(floor(floor((time-10n)/10n)/4)-2*floor(floor((time-10n)/10n)/8))-1)
B4 p4 0 V = 0.75 + 0.75*u(time-10n)*(2*(floor(floor((time-10n)/10n)/8)-2*floor(floor((time-10n)/10n)/16))-1)
B5 p5 0 V = 0.75 + 0.75*u(time-10n)*(2*(floor(floor((time-10n)/10n)/16)-2*floor(floor((time-10n)/10n)/32))-1)
B6 p6 0 V = 0.75 + 0.75*u(time-10n)*(2*(floor(floor((time-10n)/10n)/32)-2*floor(floor((time-10n)/10n)/64))-1)
B7 p7 0 V = 0.75 + 0.75*u(time-10n)*(2*(floor(floor((time-10n)/10n)/64)-2*floor(floor((time-10n)/10n)/128))-1)
B8 p8 0 V = 0.75 + 0.75*u(time-10n)*(2*(floor(floor((time-10n)/10n)/128)-2*floor(floor((time-10n)/10n)/256))-1)
B9 p9 0 V = 0.75 + 0.75*u(time-10n)*(2*(floor(floor((time-10n)/10n)/256)-2*floor(floor((time-10n)/10n)/512))-1)
B10 p10 0 V = 0.75 + 0.75*u(time-10n)*(2*(floor(floor((time-10n)/10n)/512)-2*floor(floor((time-10n)/10n)/1024))-1)
.ic v(m)=0.75 v(l)=0.75
.tran 5n 10250n 0 5n uic
.print tran v(m)
.end
