The capacitance the bottom-plate drivers hang on an idle bit's two plate nodes (M4e-kick, #10942)
* specs/analog/decks/sar_kick_cnode.cir -- one bit of the golden SAR ADC's bottom-plate logic, idle: DAC_control (its inverter, its tgate x2 to VCM, the tgates x3 and x8, two dffs) and
* neg_bottom_plate_logic (the tgates x11 and x10 and x15, the inverters x12, x13, x14) of the uberWAVE golden deck (wp2-parser/golden/top.spice, GPL-2.0: read at run time, never
* vendored; the subcircuits come from the run-time file SAR_GOLDEN_SUBCKTS, made as in sar_off_base.cir), with its clock CK11 low so that the bit is idle: Bit (the P half's plate node) is held at VCM
* by the tgate x2 and Bit_n (the N half's) reaches Bit through the tgate x11. The two plate nodes are the two ports; the DAC's capacitors are NOT here (they are the capacitor network's own),
* so what is measured is what the drivers add to the nodes: junction, overlap and channel charge of the devices of the golden subcircuits at the idle bias, through the PSP103 model (OSDI).
* Each port is held at 0.75 V by a source with a 1 V small-signal part in turn and the current of both sources is read at 100 MHz (and 300 MHz): the admittance matrix Y = G + j w C of the two-port.
* It prints, between BEGIN y and END y, one row per run (port 1 excited, port 2 excited) and frequency: the real and imaginary parts of the two currents into the ports, in A (volts are 1).
* The network model reads C11 + C12 (Bit to ground), C22 + C21 (Bit_n to ground) and -C12 (Bit to Bit_n), C_ij = Im Y_ij / w; Re Y11 is 1 / R(x2) + 1 / R(x11) and -Re Y12 = 1 / R(x11):
* the tgates' resistances (sar_off_ron.cir measures one at 10 mV) again, in situ.
* Paths are NOT in this file: IHP_PDK, IHP_OSDI and SAR_GOLDEN_SUBCKTS as in sar_off_base.cir. Run: ngspice -b sar_kick_cnode.cir   (ngspice-47, seconds). TEMP 50 as in the golden deck.
.lib $IHP_PDK/ihp-sg13g2/libs.tech/ngspice/models/cornerMOSlv.lib mos_tt
.lib $IHP_PDK/ihp-sg13g2/libs.tech/ngspice/models/cornerCAP.lib cap_typ
.include $SAR_GOLDEN_SUBCKTS
VDD vdd 0 1.5
VCM vcm 0 0.75
VCK ck 0 0
VIN vin 0 0.75
VCLK clks 0 0
VST set 0 0
VRS reset 0 0
XD vdd 0 sar vcm bitp vin ck set reset clks DAC_control
XN vdd 0 ck bitp bitn neg_bottom_plate_logic
VPB bitp 0 0.75 ac 1
VNB bitn 0 0.75 ac 0
.options temp=50
.control
pre_osdi $IHP_OSDI/psp103.osdi
pre_osdi $IHP_OSDI/psp103_nqs.osdi
set numdgt=8
echo BEGIN y
foreach fr 1e8 3e8
  alter vpb ac = 1
  alter vnb ac = 0
  ac lin 1 $fr $fr
  echo PORT1 $fr
  print i(vpb) i(vnb)
  alter vpb ac = 0
  alter vnb ac = 1
  ac lin 1 $fr $fr
  echo PORT2 $fr
  print i(vpb) i(vnb)
end
echo END y
.endc
.end
