m5b read back of a sar trace raw file
* specs/analog/decks/sar_trace_raw.cir -- the read-back of specs/analog/sar_trace_raw.t27 (#11148). The deck simulates nothing: its one resistor only gives
* ngspice a circuit, and the control block loads RAW files, prints them and writes them back, so that the doubles ngspice read can be compared with the doubles
* the spec pins. Run: ngspice -b sar_trace_raw.cir   (from a directory that holds the four files below; ngspice-47 exits 1, "incomplete or empty netlist", after the
* control block has run, because the deck has no analysis).
* The files are decoded from the text of the spec, not written by another program:
*   sar_trace_bin.raw   the constants TR_BIN_H0, TR_BIN_H1, TR_BIN_H2 joined and read as hex (500 bytes), for example
*                       grep '^pub const TR_BIN_H' specs/analog/sar_trace_raw.t27 | sed 's/.*= "//; s/";$//' | tr -d '\n' | xxd -r -p > sar_trace_bin.raw
*   sar_trace_asc.raw   the constants TR_ASC0, TR_ASC1, TR_ASC2 joined, with the escapes \t and \n read as a tab and a line feed (1004 bytes)
*   flip_bin.raw        sar_trace_bin.raw with the lowest bit of byte 356 (the first byte of v(vdn) at point 3) flipped: the spec's changed-byte control
*   short_bin.raw       sar_trace_bin.raw with the line "No. Points: 8" changed to "No. Points: 9": the spec's wrong-point-count control
* ngspice names the plots tran1 .. tran3 as it loads them and writes the variables of a loaded plot in its own order (time, code, v(vdn), v(vdp)); rb_bin.raw and
* rb_asc.raw are the binary files it writes back.
R1 1 0 1k
.control
version
set numdgt=16
echo ==== BINARY: load
load sar_trace_bin.raw
echo ==== BINARY: display
display
echo ==== BINARY: print all
print all
set filetype=binary
write rb_bin.raw all
echo ==== ASCII: load
load sar_trace_asc.raw
echo ==== ASCII: display
display
echo ==== ASCII: print all
print all
set filetype=binary
write rb_asc.raw all
echo ==== FLIPPED BYTE: load
load flip_bin.raw
echo ==== FLIPPED BYTE: print all
print all
echo ==== WRONG POINT COUNT: load
load short_bin.raw
echo ==== WRONG POINT COUNT: print all
print all
echo ==== DONE
.endc
.end
