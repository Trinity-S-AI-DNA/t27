M0 RC low-pass, backward Euler on a fixed 50 ns grid
* specs/analog/decks/rc_fixed.cir -- test data for specs/analog/bench.t27 (#10505). A plain netlist, no .control block.
* Circuit: R1 = 1 kOhm from IN to node 1 (OUT), C1 = 1 nF from node 1 to ground, OUT starts at 0 V
* (specs/fpga/rc_filter_ax7203.t27; node numbers as in specs/analog/linear.t27).
* Run: 200 steps of 50 ns, IN = 1 V for the first 100 steps and 0 V for the next 100 (vin_at of linear.t27).
* How the grid is made exact. ngspice opens every .tran with steps of tstep/100 that double up to tmax, and opens that
* ramp again after every breakpoint, so a PWL or PULSE source puts internal points off the grid. A B source declares no
* breakpoint. While the source is 0 V the circuit rests at 0 V and every step of the ramp leaves it at exactly 0 V, so the
* ramp cannot touch the state. The source turns on at 425 ns, half a step from the nearest grid point; from the first
* internal point after 425 ns every step is 50 ns. Step k of the run (k = 0..199) ends at the k-th internal point after
* 425 ns; the source is 1 V until 5425 ns and 0 V after. tstop = 425 ns + 201 steps.
* Integration: gear with maxord 1 is backward Euler. trtol = 1e7 stops the truncation test from shrinking a step.
* Run: ngspice -b -r rc_fixed.raw rc_fixed.cir   (the raw file holds float64 values)
B1 in 0 V = u(time-425n) - u(time-5425n)
R1 in 1 1k
C1 1 0 1n IC=0
.options method=gear maxord=1 trtol=1e7
.tran 50n 10475n 0 50n uic
.end
