The golden comparator and its clock generator at the first decision's clock edge, the two gates held (M4e-kick, #10942)
* specs/analog/decks/sar_kick_edge.cir -- the golden dynamic_comparator_top, SAR_logic and clock_gen of the SAR ADC deck of uberWAVE (wp2-parser/golden/top.spice, GPL-2.0: fetched at run
* time, never vendored; the subcircuits come from the run-time file SAR_GOLDEN_SUBCKTS, made as in sar_off_base.cir) with the two top plates replaced by ideal sources, so that what the
* input pair does at the clock edge is read with nothing in the way: the tail node net1, the drains ap and an, and the charge the gates take from the plates. The sources reach the plates'
* level of the first decision, vg = 0.742 V (VDP 0.739 V and VDN 0.745 V in sar_off_base.cir), along vg (1 - exp(-t / tp)) with tp = 14 ns: the tracking switch of the golden deck settles the
* plates in that time, and net1, which floats in the clock's low phase and is charged by the pair's subthreshold current from the drains, is where that history leaves it at the edge:
* 0.654 V here at 97.6 ns, 0.659 V in sar_off_base.cir at 98 ns (read from its x3.x1.net1). Each gate's source is read through a zero-volt meter (VMP, VMN): its current is the gate current.
* Everything else is sar_off_base.cir's: supplies, the clks pulse of the sampling clock, the 4 fF loads on clkc, the comparator outputs, valid, ck1, a b c and clks; the first decision's
* clock edge comes 99.3 ns after the start (clkc crosses 0.1 V at 99.307 ns and 0.75 V at 103.118 ns in this deck, 103.102 ns in sar_off_base.cir with the plates moving).
* Paths are NOT in this file: IHP_PDK (the IHP-Open-PDK checkout, commit 21133f21), IHP_OSDI (the directory with the compiled psp103.osdi, psp103_nqs.osdi, r3_cmc.osdi, mosvar.osdi,
* cap_cmomi.osdi, cap_cmomf.osdi) and SAR_GOLDEN_SUBCKTS, in the environment. Run: IHP_PDK=<checkout> IHP_OSDI=<osdi dir> SAR_GOLDEN_SUBCKTS=<file> ngspice -b sar_kick_edge.cir  (ngspice-47, seconds)
* It prints, between BEGIN wave and END wave, 67 rows at 0.1 ns from 97.8 ns to 104.4 ns (index k: time 97.8 ns + 0.1 ns k): the tail node n1 and the drain ap in volts, an
* (equal to ap to 1 uV: the plates are alike) and the charge the gate of VDP has taken from its source since 97.8 ns, in coulomb, qg = the integral of i(VMP) dt; and the crossing times tc01, tc075.
.param vg=0.742
.param tp=14n
.lib $IHP_PDK/ihp-sg13g2/libs.tech/ngspice/models/cornerMOSlv.lib mos_tt
.lib $IHP_PDK/ihp-sg13g2/libs.tech/ngspice/models/cornerCAP.lib cap_typ
.include $SAR_GOLDEN_SUBCKTS
VDD4 vdda 0 1.5
VDD6 vdd 0 1.5
VDD1 vss 0 0
V2 c 0 0
V5 b 0 0
V6 a 0 0
VCLKS clks 0 PULSE(0 1.5 0n 2n 2n 80n 500n)
BPD vdpi 0 V = {vg}*(1-exp(-time/{tp}))
BND vdni 0 V = {vg}*(1-exp(-time/{tp}))
VMP vdpi vdp 0
VMN vdni vdn 0
x3 vocp vocn valid vdp vdn clkc vdd 0 dynamic_comparator_top
x7 ck3 ck11 ck7 ck2 ck6 ck10 ck1 ck9 ck5 ck8 ck4 vdd 0 vdd valid 0 clks SAR_logic
x4 vdd clkc 0 clks valid ck1 a b c clock_gen
C9 clkc 0 4f
C10 vocp 0 4f
C11 valid 0 4f
C12 vocn 0 4f
C13 clkc 0 4f
C14 clks 0 4f
C15 valid 0 4f
C16 ck1 0 4f
C17 a 0 4f
C18 b 0 4f
C19 c 0 4f
C20 clks 0 4f
C21 valid 0 4f
.options temp=50
.options klu
.control
pre_osdi $IHP_OSDI/psp103.osdi
pre_osdi $IHP_OSDI/psp103_nqs.osdi
pre_osdi $IHP_OSDI/r3_cmc.osdi
pre_osdi $IHP_OSDI/mosvar.osdi
pre_osdi $IHP_OSDI/cap_cmomi.osdi
pre_osdi $IHP_OSDI/cap_cmomf.osdi
set num_threads=4
tran 0.05n 107n
meas tran tc01 when v(clkc)=0.1 rise=1
meas tran tc075 when v(clkc)=0.75 rise=1
linearize v(x3.x1.net1) v(x3.x1.ap) v(x3.x1.an) i(vmp)
let qint = integ(i(vmp))
let n1w = unitvec(67)
let apw = unitvec(67)
let anw = unitvec(67)
let qgw = unitvec(67)
let k = 0
while k < 67
  let j = 1956 + 2*k
  let n1w[k] = v(x3.x1.net1)[j]
  let apw[k] = v(x3.x1.ap)[j]
  let anw[k] = v(x3.x1.an)[j]
  let qgw[k] = qint[j] - qint[1956]
  let k = k + 1
end
set numdgt=8
set noprintscale
echo BEGIN wave
print n1w apw anw qgw
echo END wave
.endc
.end
