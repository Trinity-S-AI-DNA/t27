SAR gate arcs: inverter, nor, nor3, nand and tgate delays of the golden SAR deck, PSP103 tt at 50 C, fanout banks 1 4 16
* specs/analog/decks/sar_gate_arcs.cir -- reference data for specs/analog/sar_logic.t27 (M4d, #10754, epic #10486). Each gate of the golden SAR
* deck (uberWAVE wp2-parser/golden/top.spice, GPL-2.0: fetched at run time, never vendored) drives a FANOUT BANK of its own inverter
* (m = 1, 4 or 16 inverter inputs, 1.8 um^2 of gate each), and the delay from the input's 50 % point to the output's 50 % point is measured
* for every input pin and both edges. From the three loads the spec fits delay = d0 + k * FO (fanout).
* Paths are NOT in this file: ngspice reads IHP_PDK (the IHP-Open-PDK checkout), IHP_OSDI (the directory with the compiled psp103.osdi
* and psp103_nqs.osdi) and SAR_GOLDEN_SUBCKTS (the subcircuit section of the golden deck, made at run time:
*   sed -n '/^.subckt tracking_switch/,$p' top.spice | grep -v -i -E '^.(end|global)' > $SAR_GOLDEN_SUBCKTS )  from the environment.
* Run: IHP_PDK=<checkout> IHP_OSDI=<osdi dir> SAR_GOLDEN_SUBCKTS=<file> ngspice -b sar_gate_arcs.cir   (ngspice-47)
* It prints one line per arc: <name> = <seconds> . Names: d_<gate>_<pin>_<load>_<r|f> with r|f the OUTPUT edge; tgate: d_tgp (pass), d_tge (enable).
* Model, corner and temperature: sg13_lv devices, mos_tt, 50 C (the golden deck says .options TEMP = 50). Edges: 0.2 ns, 10 ns apart from 40 ns.
.lib $IHP_PDK/ihp-sg13g2/libs.tech/ngspice/models/cornerMOSlv.lib mos_tt
.include $SAR_GOLDEN_SUBCKTS
VDD vdd 0 1.5
Vlo lo 0 0
Vhi hi 0 1.5
Vin in 0 PULSE(0 1.5 10n 0.2n 0.2n 40n 200n)
Vck ck 0 PULSE(0 1.5 10n 0.2n 0.2n 40n 200n)
Vckn ckn 0 PULSE(1.5 0 10n 0.2n 0.2n 40n 200n)
xd_inv_1 in vdd 0 y_inv_1 inverter
xl_inv_1 y_inv_1 vdd 0 z_inv_1 inverter m=1
xd_nora_1 in lo y_nora_1 vdd 0 nor
xl_nora_1 y_nora_1 vdd 0 z_nora_1 inverter m=1
xd_norb_1 lo in y_norb_1 vdd 0 nor
xl_norb_1 y_norb_1 vdd 0 z_norb_1 inverter m=1
xd_nor3a_1 vdd 0 y_nor3a_1 in lo lo nor3
xl_nor3a_1 y_nor3a_1 vdd 0 z_nor3a_1 inverter m=1
xd_nor3b_1 vdd 0 y_nor3b_1 lo in lo nor3
xl_nor3b_1 y_nor3b_1 vdd 0 z_nor3b_1 inverter m=1
xd_nor3c_1 vdd 0 y_nor3c_1 lo lo in nor3
xl_nor3c_1 y_nor3c_1 vdd 0 z_nor3c_1 inverter m=1
xd_nanda_1 in hi vdd y_nanda_1 0 nand
xl_nanda_1 y_nanda_1 vdd 0 z_nanda_1 inverter m=1
xd_nandb_1 hi in vdd y_nandb_1 0 nand
xl_nandb_1 y_nandb_1 vdd 0 z_nandb_1 inverter m=1
xd_tgp_1 lo hi in y_tgp_1 vdd 0 tgate
xl_tgp_1 y_tgp_1 vdd 0 z_tgp_1 inverter m=1
xi_tgef_1 ck vdd 0 nck_tgef_1 inverter
xj_tgef_1 nck_tgef_1 vdd 0 zj_tgef_1 inverter m=2
xd_tgef_1 nck_tgef_1 ck lo y_tgef_1 vdd 0 tgate
xl_tgef_1 y_tgef_1 vdd 0 z_tgef_1 inverter m=1
.ic v(y_tgef_1)=1.5
xi_tger_1 ckn vdd 0 nck_tger_1 inverter
xj_tger_1 nck_tger_1 vdd 0 zj_tger_1 inverter m=2
xd_tger_1 ckn nck_tger_1 hi y_tger_1 vdd 0 tgate
xl_tger_1 y_tger_1 vdd 0 z_tger_1 inverter m=1
.ic v(y_tger_1)=0
xd_inv_4 in vdd 0 y_inv_4 inverter
xl_inv_4 y_inv_4 vdd 0 z_inv_4 inverter m=4
xd_nora_4 in lo y_nora_4 vdd 0 nor
xl_nora_4 y_nora_4 vdd 0 z_nora_4 inverter m=4
xd_norb_4 lo in y_norb_4 vdd 0 nor
xl_norb_4 y_norb_4 vdd 0 z_norb_4 inverter m=4
xd_nor3a_4 vdd 0 y_nor3a_4 in lo lo nor3
xl_nor3a_4 y_nor3a_4 vdd 0 z_nor3a_4 inverter m=4
xd_nor3b_4 vdd 0 y_nor3b_4 lo in lo nor3
xl_nor3b_4 y_nor3b_4 vdd 0 z_nor3b_4 inverter m=4
xd_nor3c_4 vdd 0 y_nor3c_4 lo lo in nor3
xl_nor3c_4 y_nor3c_4 vdd 0 z_nor3c_4 inverter m=4
xd_nanda_4 in hi vdd y_nanda_4 0 nand
xl_nanda_4 y_nanda_4 vdd 0 z_nanda_4 inverter m=4
xd_nandb_4 hi in vdd y_nandb_4 0 nand
xl_nandb_4 y_nandb_4 vdd 0 z_nandb_4 inverter m=4
xd_tgp_4 lo hi in y_tgp_4 vdd 0 tgate
xl_tgp_4 y_tgp_4 vdd 0 z_tgp_4 inverter m=4
xi_tgef_4 ck vdd 0 nck_tgef_4 inverter
xj_tgef_4 nck_tgef_4 vdd 0 zj_tgef_4 inverter m=2
xd_tgef_4 nck_tgef_4 ck lo y_tgef_4 vdd 0 tgate
xl_tgef_4 y_tgef_4 vdd 0 z_tgef_4 inverter m=4
.ic v(y_tgef_4)=1.5
xi_tger_4 ckn vdd 0 nck_tger_4 inverter
xj_tger_4 nck_tger_4 vdd 0 zj_tger_4 inverter m=2
xd_tger_4 ckn nck_tger_4 hi y_tger_4 vdd 0 tgate
xl_tger_4 y_tger_4 vdd 0 z_tger_4 inverter m=4
.ic v(y_tger_4)=0
xd_inv_16 in vdd 0 y_inv_16 inverter
xl_inv_16 y_inv_16 vdd 0 z_inv_16 inverter m=16
xd_nora_16 in lo y_nora_16 vdd 0 nor
xl_nora_16 y_nora_16 vdd 0 z_nora_16 inverter m=16
xd_norb_16 lo in y_norb_16 vdd 0 nor
xl_norb_16 y_norb_16 vdd 0 z_norb_16 inverter m=16
xd_nor3a_16 vdd 0 y_nor3a_16 in lo lo nor3
xl_nor3a_16 y_nor3a_16 vdd 0 z_nor3a_16 inverter m=16
xd_nor3b_16 vdd 0 y_nor3b_16 lo in lo nor3
xl_nor3b_16 y_nor3b_16 vdd 0 z_nor3b_16 inverter m=16
xd_nor3c_16 vdd 0 y_nor3c_16 lo lo in nor3
xl_nor3c_16 y_nor3c_16 vdd 0 z_nor3c_16 inverter m=16
xd_nanda_16 in hi vdd y_nanda_16 0 nand
xl_nanda_16 y_nanda_16 vdd 0 z_nanda_16 inverter m=16
xd_nandb_16 hi in vdd y_nandb_16 0 nand
xl_nandb_16 y_nandb_16 vdd 0 z_nandb_16 inverter m=16
xd_tgp_16 lo hi in y_tgp_16 vdd 0 tgate
xl_tgp_16 y_tgp_16 vdd 0 z_tgp_16 inverter m=16
xi_tgef_16 ck vdd 0 nck_tgef_16 inverter
xj_tgef_16 nck_tgef_16 vdd 0 zj_tgef_16 inverter m=2
xd_tgef_16 nck_tgef_16 ck lo y_tgef_16 vdd 0 tgate
xl_tgef_16 y_tgef_16 vdd 0 z_tgef_16 inverter m=16
.ic v(y_tgef_16)=1.5
xi_tger_16 ckn vdd 0 nck_tger_16 inverter
xj_tger_16 nck_tger_16 vdd 0 zj_tger_16 inverter m=2
xd_tger_16 ckn nck_tger_16 hi y_tger_16 vdd 0 tgate
xl_tger_16 y_tger_16 vdd 0 z_tger_16 inverter m=16
.ic v(y_tger_16)=0
xd_invc_4 in vdd 0 y_invc_4 inverter
C_invc_4 y_invc_4 0 4f
xd_invc_8 in vdd 0 y_invc_8 inverter
C_invc_8 y_invc_8 0 8f
xd_invc_16 in vdd 0 y_invc_16 inverter
C_invc_16 y_invc_16 0 16f
xd_invc_32 in vdd 0 y_invc_32 inverter
C_invc_32 y_invc_32 0 32f
.temp 50
.options reltol=1e-4
.tran 2p 100n 0 20p
.control
pre_osdi $IHP_OSDI/psp103.osdi
pre_osdi $IHP_OSDI/psp103_nqs.osdi
set numdgt=6
run
meas tran d_inv_a_1_r trig v(in) val=0.75 fall=1 targ v(y_inv_1) val=0.75 rise=1
meas tran d_inv_a_1_f trig v(in) val=0.75 rise=1 targ v(y_inv_1) val=0.75 fall=1
meas tran d_nor_a_1_r trig v(in) val=0.75 fall=1 targ v(y_nora_1) val=0.75 rise=1
meas tran d_nor_a_1_f trig v(in) val=0.75 rise=1 targ v(y_nora_1) val=0.75 fall=1
meas tran d_nor_b_1_r trig v(in) val=0.75 fall=1 targ v(y_norb_1) val=0.75 rise=1
meas tran d_nor_b_1_f trig v(in) val=0.75 rise=1 targ v(y_norb_1) val=0.75 fall=1
meas tran d_nor3_a_1_r trig v(in) val=0.75 fall=1 targ v(y_nor3a_1) val=0.75 rise=1
meas tran d_nor3_a_1_f trig v(in) val=0.75 rise=1 targ v(y_nor3a_1) val=0.75 fall=1
meas tran d_nor3_b_1_r trig v(in) val=0.75 fall=1 targ v(y_nor3b_1) val=0.75 rise=1
meas tran d_nor3_b_1_f trig v(in) val=0.75 rise=1 targ v(y_nor3b_1) val=0.75 fall=1
meas tran d_nor3_c_1_r trig v(in) val=0.75 fall=1 targ v(y_nor3c_1) val=0.75 rise=1
meas tran d_nor3_c_1_f trig v(in) val=0.75 rise=1 targ v(y_nor3c_1) val=0.75 fall=1
meas tran d_nand_a_1_r trig v(in) val=0.75 fall=1 targ v(y_nanda_1) val=0.75 rise=1
meas tran d_nand_a_1_f trig v(in) val=0.75 rise=1 targ v(y_nanda_1) val=0.75 fall=1
meas tran d_nand_b_1_r trig v(in) val=0.75 fall=1 targ v(y_nandb_1) val=0.75 rise=1
meas tran d_nand_b_1_f trig v(in) val=0.75 rise=1 targ v(y_nandb_1) val=0.75 fall=1
meas tran d_tgp_1_r trig v(in) val=0.75 rise=1 targ v(y_tgp_1) val=0.75 rise=1
meas tran d_tgp_1_f trig v(in) val=0.75 fall=1 targ v(y_tgp_1) val=0.75 fall=1
meas tran d_tge_1_f trig v(ck) val=0.75 rise=1 targ v(y_tgef_1) val=0.75 fall=1
meas tran d_tge_1_r trig v(ckn) val=0.75 fall=1 targ v(y_tger_1) val=0.75 rise=1
meas tran d_inv_a_4_r trig v(in) val=0.75 fall=1 targ v(y_inv_4) val=0.75 rise=1
meas tran d_inv_a_4_f trig v(in) val=0.75 rise=1 targ v(y_inv_4) val=0.75 fall=1
meas tran d_nor_a_4_r trig v(in) val=0.75 fall=1 targ v(y_nora_4) val=0.75 rise=1
meas tran d_nor_a_4_f trig v(in) val=0.75 rise=1 targ v(y_nora_4) val=0.75 fall=1
meas tran d_nor_b_4_r trig v(in) val=0.75 fall=1 targ v(y_norb_4) val=0.75 rise=1
meas tran d_nor_b_4_f trig v(in) val=0.75 rise=1 targ v(y_norb_4) val=0.75 fall=1
meas tran d_nor3_a_4_r trig v(in) val=0.75 fall=1 targ v(y_nor3a_4) val=0.75 rise=1
meas tran d_nor3_a_4_f trig v(in) val=0.75 rise=1 targ v(y_nor3a_4) val=0.75 fall=1
meas tran d_nor3_b_4_r trig v(in) val=0.75 fall=1 targ v(y_nor3b_4) val=0.75 rise=1
meas tran d_nor3_b_4_f trig v(in) val=0.75 rise=1 targ v(y_nor3b_4) val=0.75 fall=1
meas tran d_nor3_c_4_r trig v(in) val=0.75 fall=1 targ v(y_nor3c_4) val=0.75 rise=1
meas tran d_nor3_c_4_f trig v(in) val=0.75 rise=1 targ v(y_nor3c_4) val=0.75 fall=1
meas tran d_nand_a_4_r trig v(in) val=0.75 fall=1 targ v(y_nanda_4) val=0.75 rise=1
meas tran d_nand_a_4_f trig v(in) val=0.75 rise=1 targ v(y_nanda_4) val=0.75 fall=1
meas tran d_nand_b_4_r trig v(in) val=0.75 fall=1 targ v(y_nandb_4) val=0.75 rise=1
meas tran d_nand_b_4_f trig v(in) val=0.75 rise=1 targ v(y_nandb_4) val=0.75 fall=1
meas tran d_tgp_4_r trig v(in) val=0.75 rise=1 targ v(y_tgp_4) val=0.75 rise=1
meas tran d_tgp_4_f trig v(in) val=0.75 fall=1 targ v(y_tgp_4) val=0.75 fall=1
meas tran d_tge_4_f trig v(ck) val=0.75 rise=1 targ v(y_tgef_4) val=0.75 fall=1
meas tran d_tge_4_r trig v(ckn) val=0.75 fall=1 targ v(y_tger_4) val=0.75 rise=1
meas tran d_inv_a_16_r trig v(in) val=0.75 fall=1 targ v(y_inv_16) val=0.75 rise=1
meas tran d_inv_a_16_f trig v(in) val=0.75 rise=1 targ v(y_inv_16) val=0.75 fall=1
meas tran d_nor_a_16_r trig v(in) val=0.75 fall=1 targ v(y_nora_16) val=0.75 rise=1
meas tran d_nor_a_16_f trig v(in) val=0.75 rise=1 targ v(y_nora_16) val=0.75 fall=1
meas tran d_nor_b_16_r trig v(in) val=0.75 fall=1 targ v(y_norb_16) val=0.75 rise=1
meas tran d_nor_b_16_f trig v(in) val=0.75 rise=1 targ v(y_norb_16) val=0.75 fall=1
meas tran d_nor3_a_16_r trig v(in) val=0.75 fall=1 targ v(y_nor3a_16) val=0.75 rise=1
meas tran d_nor3_a_16_f trig v(in) val=0.75 rise=1 targ v(y_nor3a_16) val=0.75 fall=1
meas tran d_nor3_b_16_r trig v(in) val=0.75 fall=1 targ v(y_nor3b_16) val=0.75 rise=1
meas tran d_nor3_b_16_f trig v(in) val=0.75 rise=1 targ v(y_nor3b_16) val=0.75 fall=1
meas tran d_nor3_c_16_r trig v(in) val=0.75 fall=1 targ v(y_nor3c_16) val=0.75 rise=1
meas tran d_nor3_c_16_f trig v(in) val=0.75 rise=1 targ v(y_nor3c_16) val=0.75 fall=1
meas tran d_nand_a_16_r trig v(in) val=0.75 fall=1 targ v(y_nanda_16) val=0.75 rise=1
meas tran d_nand_a_16_f trig v(in) val=0.75 rise=1 targ v(y_nanda_16) val=0.75 fall=1
meas tran d_nand_b_16_r trig v(in) val=0.75 fall=1 targ v(y_nandb_16) val=0.75 rise=1
meas tran d_nand_b_16_f trig v(in) val=0.75 rise=1 targ v(y_nandb_16) val=0.75 fall=1
meas tran d_tgp_16_r trig v(in) val=0.75 rise=1 targ v(y_tgp_16) val=0.75 rise=1
meas tran d_tgp_16_f trig v(in) val=0.75 fall=1 targ v(y_tgp_16) val=0.75 fall=1
meas tran d_tge_16_f trig v(ck) val=0.75 rise=1 targ v(y_tgef_16) val=0.75 fall=1
meas tran d_tge_16_r trig v(ckn) val=0.75 fall=1 targ v(y_tger_16) val=0.75 rise=1
meas tran d_invc_4_r trig v(in) val=0.75 fall=1 targ v(y_invc_4) val=0.75 rise=1
meas tran d_invc_4_f trig v(in) val=0.75 rise=1 targ v(y_invc_4) val=0.75 fall=1
meas tran d_invc_8_r trig v(in) val=0.75 fall=1 targ v(y_invc_8) val=0.75 rise=1
meas tran d_invc_8_f trig v(in) val=0.75 rise=1 targ v(y_invc_8) val=0.75 fall=1
meas tran d_invc_16_r trig v(in) val=0.75 fall=1 targ v(y_invc_16) val=0.75 rise=1
meas tran d_invc_16_f trig v(in) val=0.75 rise=1 targ v(y_invc_16) val=0.75 fall=1
meas tran d_invc_32_r trig v(in) val=0.75 fall=1 targ v(y_invc_32) val=0.75 rise=1
meas tran d_invc_32_f trig v(in) val=0.75 rise=1 targ v(y_invc_32) val=0.75 fall=1
.endc
.end
