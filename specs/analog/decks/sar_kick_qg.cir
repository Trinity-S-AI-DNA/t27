The gate charge of the comparator's input device, bulk on ground, at 50 C: Q_G(Vg, Vs, Vd) on three gate levels, 25 x 25 each (M4e-kick, #10942)
* specs/analog/decks/sar_kick_qg.cir -- the input pair of the golden dynamic comparator (XM3, XM4: sg13_lv_nmos W 1.0 um, L 0.45 um, 36 in parallel) has its bulk on VSS and its source on the tail
* node, which sits 0.2 .. 0.7 V above ground while it falls at the clock edge; M3c's gate-charge table (psp103_q_tt.cir, TT_QG_N) is for the bulk tied to the source and 27 C. This deck is that
* recipe with the two things the comparator has: the bulk at 0 V and TEMP 50 (the golden deck's `.options temp=50`), and with the gate as a third axis. The gate sits at one of three levels,
* Vg = 0.742 V + (jg - 1) * 25 mV (jg = 0, 1, 2: 0.717, 0.742, 0.767 V; the plates of the first decision rest at 0.74 V and move by tens of millivolts), the SOURCE is on a staircase of 25 levels,
* Vs = ix * 31.25 mV, and the drain on 25 levels, Vd = iy * 62.5 mV; the index is jg * 625 + ix * 25 + iy. Each node of the grid is visited from ONE origin (Vg = 0.742 V, Vs = Vd = 0) for 10 ns
* and the bias returns to the origin for 10 ns, and the gate's terminal current at the end of the return step, against the one before the first jump, is the gate charge
* Q_G(Vg, Vs, Vd) - Q_G(0.742, 0, 0) of M3c's recipe: Q(B) - Q(A) = (i_A - i_return) dt (the gate current is a few pA at the origin, where the device conducts with Vds = 0, so no
* DC current needs subtracting). Because the origin is the same for the three levels, a difference of two levels is the charge a change of the gate moves. The unit and the offset are M3c's:
* one unit is Q / 500 fF in 2^-24 V (2.98e-20 C), entry = nint(2e12 * 2^24 * (Q(B) - Q(A))) + 2^21, for the one device (m = 1); the comparator's pair is 36 of them.
* Model: IHP-Open-PDK commit 21133f219b1a6da10d803e345761e77415ceff40, mos_tt (PSP 103.6), the OSDI models psp103.osdi and psp103_nqs.osdi compiled from the same commit.
* Paths are NOT in this file: ngspice reads IHP_PDK (the checkout) and IHP_OSDI (the directory of the compiled .osdi files).
* Run: IHP_PDK=<checkout> IHP_OSDI=<osdi dir> ngspice -b sar_kick_qg.cir     (ngspice-47, seconds)
* It prints, between BEGIN qg and END qg, the 1875 entries, and between BEGIN cap_o and END cap_o the gate capacitances ngspice itself reports at one operating point (Vg 0.742, Vs 0.4,
* Vd 1.3, in aF) as a cross-check.
.lib $IHP_PDK/ihp-sg13g2/libs.tech/ngspice/models/cornerMOSlv.lib mos_tt
.func kst() {nint(time/1e-8)}
.func nd() {max(floor(kst()/2)-1,0)}
.func act() {(time<1e-3)*(kst()>=2)*((kst()-2*floor(kst()/2))==0)}
.func jgf() {floor(nd()/625)}
.func ixf() {floor((nd()-625*jgf())/25)}
.func iyf() {nd()-625*jgf()-25*ixf()}
BSN tsn 0 V = act()*0.03125*ixf()
BDN tdn 0 V = act()*0.0625*iyf()
BGN tgn 0 V = 0.742+act()*0.025*(jgf()-1)
VMGN tgn tgnn 0
XTN tdn tgnn tsn 0 sg13_lv_nmos w=1.0u l=0.45u ng=1 m=1
* a second copy at one fixed bias, for ngspice's own capacitances
VSO so 0 0.4
VDO dO 0 1.3
VGO go 0 0.742
XMO dO go so 0 sg13_lv_nmos w=1.0u l=0.45u ng=1 m=1
.options temp=50
.options reltol=1e-6 vntol=1e-9 abstol=1e-14
.options method=gear maxord=1 trtol=1e7 itl4=200
.control
pre_osdi $IHP_OSDI/psp103.osdi
pre_osdi $IHP_OSDI/psp103_nqs.osdi
set numdgt=10
set noprintscale
op
let c_gg = nint(@n.xmo.nsg13_lv_nmos[cgg] * 1e18)
let c_gsol = nint(@n.xmo.nsg13_lv_nmos[cgsol] * 1e18)
let c_gdol = nint(@n.xmo.nsg13_lv_nmos[cgdol] * 1e18)
echo BEGIN cap_o
print c_gg c_gsol c_gdol
echo END cap_o
tran 7.8125n 37.6u 0 10n
let g0 = i(vmgn)[8]
let qgn = unitvec(1875)
let tchk = abs(time[8] - 1e-8)
let k = 0
while k < 1875
  let r = 2*k + 10
  let tchk = max(tchk, abs(time[r] - (2*k+3)*1e-8))
  let qgn[k] = nint((g0 - i(vmgn)[r]) * 1e-8 * 2e12 * 16777216) + 2097152
  let k = k + 1
end
echo BEGIN qg
print qgn
echo END qg
echo BEGIN tchk
print tchk
echo END tchk
.endc
.end
