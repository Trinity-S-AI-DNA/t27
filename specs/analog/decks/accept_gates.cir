IHP SG13G2 two-input gates and the transmission gate off, DC: output levels and off leakage, corner mos_tt, 27 C
* specs/analog/decks/accept_gates.cir -- reference data for specs/analog/mos_psp103_gates.t27 and its use in specs/analog/accept_sar.t27 (M5d, #11263, epic #10486).
* A netlist plus a .control block that prints the numbers. The cells are the nand, the nor and the tgate of the golden SAR ADC netlist, with the W, L and m of their devices
* (nmos 1.0 um / 0.45 um, pmos 3.0 um / 0.45 um, ng 1, m 1), which are facts of the circuit; none of its text is copied. The model is the IHP SG13G2 PSP103 of
* IHP-Open-PDK 21133f21, section mos_tt, 27 C, the one of the tables in mos_psp103_data.t27. Paths are NOT in this file: ngspice reads IHP_PDK and IHP_OSDI from the environment.
* Run: IHP_PDK=<checkout> IHP_OSDI=<osdi dir> ngspice -b accept_gates.cir    (ngspice-47)
* What it prints (volts and amperes, 12 digits):
*   dnd00 dnd01 dnd10 dnr00  the 1 levels as the droop under the supply, 1.5 V minus the output, of the nand for the inputs A B = 00, 01, 10 and of the nor for 00
*   v(nd11) v(nr01) v(nr10) v(nr11)  the 0 levels, the output itself, of the nand for 11 and of the nor for 01, 10, 11
*   The levels are the DC solution with no load, which is the level a gate settles to into 10 fF.
*   i(vli1) i(vlo1)         the tgate off (pmos gate 1.5 V, nmos gate 0 V) with the input at 1.5 V and the output at 0 V: the current of the input source and of the output source (the
*   i(vli2) i(vlo2)         same with the input at 0 V and the output at 1.5 V: the two roles exchanged, so the same two numbers); the two differ by 14 pA, the size of
*                           a junction leakage, which sits in different terminals of the two sources; the terms are not separated here.
* Solver options: reltol 1e-9, vntol 1e-12, abstol 1e-15, gmin 1e-18 (no leak is added by the simulator), itl1 500: the levels are microvolts and the leakage picoamperes. At gmin 1e-18
* the operating point is reached by source stepping (ngspice says so in its log), which is the solver working, not a failure of the run.
.lib $IHP_PDK/ihp-sg13g2/libs.tech/ngspice/models/cornerMOSlv.lib mos_tt
.subckt nand2 a b vdd out vss
XM1 n1 b vss vss sg13_lv_nmos w=1.0u l=0.45u ng=1 m=1
XM2 out a n1 vss sg13_lv_nmos w=1.0u l=0.45u ng=1 m=1
XM3 out a vdd vdd sg13_lv_pmos w=3.0u l=0.45u ng=1 m=1
XM4 out b vdd vdd sg13_lv_pmos w=3.0u l=0.45u ng=1 m=1
.ends
.subckt nor2 a b vdd out vss
XM1 out a vss vss sg13_lv_nmos w=1.0u l=0.45u ng=1 m=1
XM2 out b vss vss sg13_lv_nmos w=1.0u l=0.45u ng=1 m=1
XM3 out b n1 vdd sg13_lv_pmos w=3.0u l=0.45u ng=1 m=1
XM4 n1 a vdd vdd sg13_lv_pmos w=3.0u l=0.45u ng=1 m=1
.ends
.subckt tgate clk nclk in out vdd vss
XM1 out clk in vdd sg13_lv_pmos w=3.0u l=0.45u ng=1 m=1
XM2 in nclk out vss sg13_lv_nmos w=1.0u l=0.45u ng=1 m=1
.ends
VDD vdd 0 1.5
V0 l0 0 0
V1 l1 0 1.5
Xnd00 l0 l0 vdd nd00 0 nand2
Xnd01 l0 l1 vdd nd01 0 nand2
Xnd10 l1 l0 vdd nd10 0 nand2
Xnd11 l1 l1 vdd nd11 0 nand2
Xnr00 l0 l0 vdd nr00 0 nor2
Xnr01 l0 l1 vdd nr01 0 nor2
Xnr10 l1 l0 vdd nr10 0 nor2
Xnr11 l1 l1 vdd nr11 0 nor2
Cnd00 nd00 0 10f
Cnd01 nd01 0 10f
Cnd10 nd10 0 10f
Cnd11 nd11 0 10f
Cnr00 nr00 0 10f
Cnr01 nr01 0 10f
Cnr10 nr10 0 10f
Cnr11 nr11 0 10f
* the tgate off, full swing both ways
VLI1 li1 0 1.5
VLO1 lo1 0 0
Xoff1 l1 l0 li1 lo1 vdd 0 tgate
VLI2 li2 0 0
VLO2 lo2 0 1.5
Xoff2 l1 l0 li2 lo2 vdd 0 tgate
.options temp=27 reltol=1e-9 vntol=1e-12 abstol=1e-15 gmin=1e-18 itl1=500
.control
pre_osdi $IHP_OSDI/psp103.osdi
pre_osdi $IHP_OSDI/psp103_nqs.osdi
set num_threads=2
set numdgt=12
op
let dnd00 = 1.5 - v(nd00)
let dnd01 = 1.5 - v(nd01)
let dnd10 = 1.5 - v(nd10)
let dnr00 = 1.5 - v(nr00)
echo BEGIN gates
print dnd00 dnd01 dnd10
print v(nd11)
print dnr00
print v(nr01) v(nr10) v(nr11)
print i(vli1) i(vlo1) i(vli2) i(vlo2)
echo END gates
.endc
.end
