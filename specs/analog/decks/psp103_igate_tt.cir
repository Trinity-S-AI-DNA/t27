IHP SG13G2 PSP103 mos_tt 27 C: DC gate current of one lv nmos (1.0/0.45 um) and one lv pmos (3.0/0.45 um) in the dff's stored-state biases
* specs/analog/decks/psp103_igate_tt.cir -- reference data for #11422 (M3g, epic #10486): does the foundry model carry a gate current, and how large is it
* at the biases a stored dff puts on the gates Q drives? Each device alone, terminals on ideal sources, .op only; the current into each gate source is printed.
* Device pins d g s b. Paths are NOT in this file: ngspice reads IHP_PDK and IHP_OSDI from the environment.
* Run: IHP_PDK=<checkout> IHP_OSDI=<osdi dir> ngspice -b psp103_igate_tt.cir   (ngspice-47)
* Cases (V): n_on: nmos g 1.5, d s b 0 | n_on_d: nmos g 1.5, d 1.5, s b 0 | n_off: nmos g 0, d 1.5, s b 0
*            p_off: pmos g 1.5, d s b 1.5 | p_off_d: pmos g 1.5, d 0, s b 1.5 | p_on: pmos g 0, d s b 1.5
.lib $IHP_PDK/ihp-sg13g2/libs.tech/ngspice/models/cornerMOSlv.lib mos_tt
.temp 27
.options reltol=1e-9 vntol=1e-12 abstol=1e-18 gmin=1e-18 itl1=500
VH h 0 1.5
VG1 g1 0 1.5
XN1 0 g1 0 0 sg13_lv_nmos w=1.0u l=0.45u ng=1 m=1
VG2 g2 0 1.5
XN2 h g2 0 0 sg13_lv_nmos w=1.0u l=0.45u ng=1 m=1
VG3 g3 0 0
XN3 h g3 0 0 sg13_lv_nmos w=1.0u l=0.45u ng=1 m=1
VG4 g4 0 1.5
XP4 h g4 h h sg13_lv_pmos w=3.0u l=0.45u ng=1 m=1
VG5 g5 0 1.5
XP5 0 g5 h h sg13_lv_pmos w=3.0u l=0.45u ng=1 m=1
VG6 g6 0 0
XP6 h g6 h h sg13_lv_pmos w=3.0u l=0.45u ng=1 m=1
.control
pre_osdi $IHP_OSDI/psp103.osdi
pre_osdi $IHP_OSDI/psp103_nqs.osdi
set numdgt=12
op
print i(vg1) i(vg2) i(vg3) i(vg4) i(vg5) i(vg6)
.endc
.end
