IHP SG13G2 inverter, 10 pF, backward Euler on a fixed 2 ns grid, corner mos_tt
* specs/analog/decks/psp103_inv_be.cir -- reference data for specs/analog/mos_psp103.t27 (M3b, #10516, epic #10486). A netlist plus a
* .control block that prints the numbers.
* Circuit: the inverter of the uberWAVE golden SAR deck (PMOS w=3.0u l=0.45u, NMOS w=1.0u l=0.45u, both sg13_lv, ng=1, m=1; Vdd 1.5 V),
* a lumped load of 10 pF on the output, no other element. Model, corner and temperature as in psp103_tab_tt.cir (IHP-Open-PDK commit
* 21133f219b1a6da10d803e345761e77415ceff40, mos_tt, 27 C). dt = 2 ns, so dt / C = 200 V/A, the scale of the tables in
* mos_psp103_data.t27. The device capacitances of PSP103 (gate-drain overlap and channel, drain junctions), which the table model does not
* have, are a few fF to some ten fF: about 0.2 % of 10 pF. psp103_inv_be_500f.cir is the same run at 500 fF, where they are 20 times
* larger in proportion.
* Paths are NOT in this file: ngspice reads IHP_PDK (the IHP-Open-PDK checkout) and IHP_OSDI (the directory with the compiled
* psp103.osdi and psp103_nqs.osdi) from the environment.
* Run: IHP_PDK=<checkout> IHP_OSDI=<osdi dir> ngspice -b psp103_inv_be.cir > psp103_inv_be.out    (ngspice-47)
* The input is a B source of nint(time / dt), a staircase that declares no breakpoint: Vdd (the output rests near 0 V) up to the
* grid point 2 ns, 0 V from 3 ns (nint = 2) up to 403 ns, Vdd again from 403 ns (nint = 202). ngspice opens the run with steps of
* tstep / 100 that double up to tmax; tstep = 0.78125 dt makes the first step 15.625 ps and the end of that ramp exactly dt = 2 ns, so every
* internal point from then on is a multiple of 2 ns. Step k (k = 0..399) of the spec ends at (k + 2) dt and sees the input of nint =
* k + 2: 0 V for k < 200, Vdd from k = 200. Integration: gear with maxord 1 is backward Euler; trtol = 1e7 stops the truncation test
* from shrinking a step; reltol, vntol and abstol are tight enough for 1e-6 V and loose enough for Newton to converge at the input steps.
* tstop is two steps past the last row used: ngspice splits a last step that would pass tstop, and that would move the last row.
* What it prints: between "BEGIN tran_be" and "END tran_be", 401 rows "<index> TAB <time> TAB <y>": y is the output in units of 2^-24 V
* (nint(v * 16777216)) at t = 2 ns, 4 ns, ... 802 ns: row 0 is the circuit at rest (t = dt, before step 0), row k + 1 is the output
* after step k. They are the rows 8 to 408 of the run (rows 0 to 7 are the opening ramp, t < dt). The spec holds the y column.
.lib $IHP_PDK/ihp-sg13g2/libs.tech/ngspice/models/cornerMOSlv.lib mos_tt
VDD vdd 0 1.5
Bin in 0 V = 1.5*(1-min(max(nint(time/2e-9)-1,0),1)+min(max(nint(time/2e-9)-201,0),1))
XIP out in vdd vdd sg13_lv_pmos w=3.0u l=0.45u ng=1 m=1
XIN out in 0 0 sg13_lv_nmos w=1.0u l=0.45u ng=1 m=1
CL out 0 10p
.temp 27
.options method=gear maxord=1 trtol=1e7 reltol=1e-6 vntol=1e-9 abstol=1e-12 itl4=200
.tran 1.5625n 804n 0 2n
.control
pre_osdi $IHP_OSDI/psp103.osdi
pre_osdi $IHP_OSDI/psp103_nqs.osdi
set numdgt=10
set noprintscale
run
let y = nint(v(out) * 16777216)
let ts = time[8,408]
let ys = y[8,408]
echo BEGIN tran_be
print ts ys
echo END tran_be
.endc
.end
