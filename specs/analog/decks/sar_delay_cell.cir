SAR clock_gen delay cell: nor3, delay_cell and inverter of the golden SAR deck for the 8 trim codes, PSP103 tt at 50 C
* specs/analog/decks/sar_delay_cell.cir -- reference data for specs/analog/sar_logic.t27 (M4d, #10754, epic #10486). Eight copies of the
* chain of clock_gen (nor3 -> delay_cell -> inverter) differ only in the trim code A B C of the delay cell (code = 4 A + 2 B + C; the golden
* top ties A = B = C = 0, which is code 0). clks falls once and rises once; Valid and CK1 of the nor3 are held low. The inverter's output
* carries the 8 fF the golden top puts on clkc. Measured from the 50 % point of each net: the nor3 output (n1), the delay cell output (n2), clkc.
* Paths are NOT in this file: ngspice reads IHP_PDK, IHP_OSDI and SAR_GOLDEN_SUBCKTS (see sar_gate_arcs.cir) from the environment.
* Run: IHP_PDK=<checkout> IHP_OSDI=<osdi dir> SAR_GOLDEN_SUBCKTS=<file> ngspice -b sar_delay_cell.cir   (ngspice-47)
* It prints one line per measure: <name> = <seconds>. Names: n1_<code>_<r|f> = clks edge -> nor3 output edge, dc_<code>_<r|f> = nor3 output edge ->
* delay cell output edge, iv_<code>_<r|f> = delay cell output edge -> clkc edge, tot_<code>_<r|f> = clks edge -> clkc edge (r|f the edge of clkc).
.lib $IHP_PDK/ihp-sg13g2/libs.tech/ngspice/models/cornerMOSlv.lib mos_tt
.include $SAR_GOLDEN_SUBCKTS
VDD vdd 0 1.5
Vlo lo 0 0
Vhi hi 0 1.5
Vclks clks 0 PULSE(1.5 0 10n 0.2n 0.2n 80n 200n)
xn0 vdd 0 n1_0 clks lo lo nor3
xd0 n2_0 vdd 0 n1_0 lo lo lo delay_cell
xi0 n2_0 vdd 0 ck_0 inverter
C0 ck_0 0 8f
xn1 vdd 0 n1_1 clks lo lo nor3
xd1 n2_1 vdd 0 n1_1 lo lo hi delay_cell
xi1 n2_1 vdd 0 ck_1 inverter
C1 ck_1 0 8f
xn2 vdd 0 n1_2 clks lo lo nor3
xd2 n2_2 vdd 0 n1_2 lo hi lo delay_cell
xi2 n2_2 vdd 0 ck_2 inverter
C2 ck_2 0 8f
xn3 vdd 0 n1_3 clks lo lo nor3
xd3 n2_3 vdd 0 n1_3 lo hi hi delay_cell
xi3 n2_3 vdd 0 ck_3 inverter
C3 ck_3 0 8f
xn4 vdd 0 n1_4 clks lo lo nor3
xd4 n2_4 vdd 0 n1_4 hi lo lo delay_cell
xi4 n2_4 vdd 0 ck_4 inverter
C4 ck_4 0 8f
xn5 vdd 0 n1_5 clks lo lo nor3
xd5 n2_5 vdd 0 n1_5 hi lo hi delay_cell
xi5 n2_5 vdd 0 ck_5 inverter
C5 ck_5 0 8f
xn6 vdd 0 n1_6 clks lo lo nor3
xd6 n2_6 vdd 0 n1_6 hi hi lo delay_cell
xi6 n2_6 vdd 0 ck_6 inverter
C6 ck_6 0 8f
xn7 vdd 0 n1_7 clks lo lo nor3
xd7 n2_7 vdd 0 n1_7 hi hi hi delay_cell
xi7 n2_7 vdd 0 ck_7 inverter
C7 ck_7 0 8f
.temp 50
.options reltol=1e-4
.tran 5p 190n 0 50p
.control
pre_osdi $IHP_OSDI/psp103.osdi
pre_osdi $IHP_OSDI/psp103_nqs.osdi
set numdgt=6
run
meas tran n1_0_r trig v(clks) val=0.75 fall=1 targ v(n1_0) val=0.75 rise=1
meas tran n1_0_f trig v(clks) val=0.75 rise=1 targ v(n1_0) val=0.75 fall=1
meas tran dc_0_f trig v(n1_0) val=0.75 rise=1 targ v(n2_0) val=0.75 fall=1
meas tran dc_0_r trig v(n1_0) val=0.75 fall=1 targ v(n2_0) val=0.75 rise=1
meas tran iv_0_r trig v(n2_0) val=0.75 fall=1 targ v(ck_0) val=0.75 rise=1
meas tran iv_0_f trig v(n2_0) val=0.75 rise=1 targ v(ck_0) val=0.75 fall=1
meas tran tot_0_r trig v(clks) val=0.75 fall=1 targ v(ck_0) val=0.75 rise=1
meas tran tot_0_f trig v(clks) val=0.75 rise=1 targ v(ck_0) val=0.75 fall=1
meas tran n1_1_r trig v(clks) val=0.75 fall=1 targ v(n1_1) val=0.75 rise=1
meas tran n1_1_f trig v(clks) val=0.75 rise=1 targ v(n1_1) val=0.75 fall=1
meas tran dc_1_f trig v(n1_1) val=0.75 rise=1 targ v(n2_1) val=0.75 fall=1
meas tran dc_1_r trig v(n1_1) val=0.75 fall=1 targ v(n2_1) val=0.75 rise=1
meas tran iv_1_r trig v(n2_1) val=0.75 fall=1 targ v(ck_1) val=0.75 rise=1
meas tran iv_1_f trig v(n2_1) val=0.75 rise=1 targ v(ck_1) val=0.75 fall=1
meas tran tot_1_r trig v(clks) val=0.75 fall=1 targ v(ck_1) val=0.75 rise=1
meas tran tot_1_f trig v(clks) val=0.75 rise=1 targ v(ck_1) val=0.75 fall=1
meas tran n1_2_r trig v(clks) val=0.75 fall=1 targ v(n1_2) val=0.75 rise=1
meas tran n1_2_f trig v(clks) val=0.75 rise=1 targ v(n1_2) val=0.75 fall=1
meas tran dc_2_f trig v(n1_2) val=0.75 rise=1 targ v(n2_2) val=0.75 fall=1
meas tran dc_2_r trig v(n1_2) val=0.75 fall=1 targ v(n2_2) val=0.75 rise=1
meas tran iv_2_r trig v(n2_2) val=0.75 fall=1 targ v(ck_2) val=0.75 rise=1
meas tran iv_2_f trig v(n2_2) val=0.75 rise=1 targ v(ck_2) val=0.75 fall=1
meas tran tot_2_r trig v(clks) val=0.75 fall=1 targ v(ck_2) val=0.75 rise=1
meas tran tot_2_f trig v(clks) val=0.75 rise=1 targ v(ck_2) val=0.75 fall=1
meas tran n1_3_r trig v(clks) val=0.75 fall=1 targ v(n1_3) val=0.75 rise=1
meas tran n1_3_f trig v(clks) val=0.75 rise=1 targ v(n1_3) val=0.75 fall=1
meas tran dc_3_f trig v(n1_3) val=0.75 rise=1 targ v(n2_3) val=0.75 fall=1
meas tran dc_3_r trig v(n1_3) val=0.75 fall=1 targ v(n2_3) val=0.75 rise=1
meas tran iv_3_r trig v(n2_3) val=0.75 fall=1 targ v(ck_3) val=0.75 rise=1
meas tran iv_3_f trig v(n2_3) val=0.75 rise=1 targ v(ck_3) val=0.75 fall=1
meas tran tot_3_r trig v(clks) val=0.75 fall=1 targ v(ck_3) val=0.75 rise=1
meas tran tot_3_f trig v(clks) val=0.75 rise=1 targ v(ck_3) val=0.75 fall=1
meas tran n1_4_r trig v(clks) val=0.75 fall=1 targ v(n1_4) val=0.75 rise=1
meas tran n1_4_f trig v(clks) val=0.75 rise=1 targ v(n1_4) val=0.75 fall=1
meas tran dc_4_f trig v(n1_4) val=0.75 rise=1 targ v(n2_4) val=0.75 fall=1
meas tran dc_4_r trig v(n1_4) val=0.75 fall=1 targ v(n2_4) val=0.75 rise=1
meas tran iv_4_r trig v(n2_4) val=0.75 fall=1 targ v(ck_4) val=0.75 rise=1
meas tran iv_4_f trig v(n2_4) val=0.75 rise=1 targ v(ck_4) val=0.75 fall=1
meas tran tot_4_r trig v(clks) val=0.75 fall=1 targ v(ck_4) val=0.75 rise=1
meas tran tot_4_f trig v(clks) val=0.75 rise=1 targ v(ck_4) val=0.75 fall=1
meas tran n1_5_r trig v(clks) val=0.75 fall=1 targ v(n1_5) val=0.75 rise=1
meas tran n1_5_f trig v(clks) val=0.75 rise=1 targ v(n1_5) val=0.75 fall=1
meas tran dc_5_f trig v(n1_5) val=0.75 rise=1 targ v(n2_5) val=0.75 fall=1
meas tran dc_5_r trig v(n1_5) val=0.75 fall=1 targ v(n2_5) val=0.75 rise=1
meas tran iv_5_r trig v(n2_5) val=0.75 fall=1 targ v(ck_5) val=0.75 rise=1
meas tran iv_5_f trig v(n2_5) val=0.75 rise=1 targ v(ck_5) val=0.75 fall=1
meas tran tot_5_r trig v(clks) val=0.75 fall=1 targ v(ck_5) val=0.75 rise=1
meas tran tot_5_f trig v(clks) val=0.75 rise=1 targ v(ck_5) val=0.75 fall=1
meas tran n1_6_r trig v(clks) val=0.75 fall=1 targ v(n1_6) val=0.75 rise=1
meas tran n1_6_f trig v(clks) val=0.75 rise=1 targ v(n1_6) val=0.75 fall=1
meas tran dc_6_f trig v(n1_6) val=0.75 rise=1 targ v(n2_6) val=0.75 fall=1
meas tran dc_6_r trig v(n1_6) val=0.75 fall=1 targ v(n2_6) val=0.75 rise=1
meas tran iv_6_r trig v(n2_6) val=0.75 fall=1 targ v(ck_6) val=0.75 rise=1
meas tran iv_6_f trig v(n2_6) val=0.75 rise=1 targ v(ck_6) val=0.75 fall=1
meas tran tot_6_r trig v(clks) val=0.75 fall=1 targ v(ck_6) val=0.75 rise=1
meas tran tot_6_f trig v(clks) val=0.75 rise=1 targ v(ck_6) val=0.75 fall=1
meas tran n1_7_r trig v(clks) val=0.75 fall=1 targ v(n1_7) val=0.75 rise=1
meas tran n1_7_f trig v(clks) val=0.75 rise=1 targ v(n1_7) val=0.75 fall=1
meas tran dc_7_f trig v(n1_7) val=0.75 rise=1 targ v(n2_7) val=0.75 fall=1
meas tran dc_7_r trig v(n1_7) val=0.75 fall=1 targ v(n2_7) val=0.75 rise=1
meas tran iv_7_r trig v(n2_7) val=0.75 fall=1 targ v(ck_7) val=0.75 rise=1
meas tran iv_7_f trig v(n2_7) val=0.75 rise=1 targ v(ck_7) val=0.75 fall=1
meas tran tot_7_r trig v(clks) val=0.75 fall=1 targ v(ck_7) val=0.75 rise=1
meas tran tot_7_f trig v(clks) val=0.75 rise=1 targ v(ck_7) val=0.75 fall=1
.endc
.end
