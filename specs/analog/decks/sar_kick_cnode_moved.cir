A moved bit's drive: the two-port the bottom-plate drivers present at Bit and Bit_n after the bit's decision, both directions (M4e-kick, #10942)
* specs/analog/decks/sar_kick_cnode_moved.cir -- sar_kick_cnode.cir with the bit MOVED instead of idle: the clock CK11 of DAC_control and neg_bottom_plate_logic high (the tgate x2 to VCM
* and x11 between the plates are off; the inverter XM3 / XM4 holds Bit, and the inverter x12 behind the tgate x15 holds Bit_n), the bit's flip-flop forced by Set or Reset, and each plate node
* held 10 mV off its rail, where the plates sit (they kick by tens of millivolts about it). Two cases: dir 0, the P plate UP (Bit at 1.49 V through the pmos, Bit_n at 0.01 V through the
* inverter x12's nmos and the tgate x15's nmos), dir 1, the P plate DOWN (Bit at 0.01 V through the nmos, Bit_n at 1.49 V through two pmos). The operating point gives the on-resistances as 10 mV / i:
* the P plate 1881 ohm up (pmos W 3 um) and 1428 ohm down (nmos W 1 um), the N plate 2862 and 3772 ohm, twice the inverter's: the golden tgate x15 at a rail is one device of the inverter's size
* again. The ac runs at 100 MHz and 300 MHz give, as sar_kick_cnode.cir does, the admittance matrix Y = G + j w C of the two plate nodes of the moved bit, the capacitances its devices add.
* Paths are NOT in this file: IHP_PDK, IHP_OSDI and SAR_GOLDEN_SUBCKTS as in sar_off_base.cir. Run: ngspice -b sar_kick_cnode_moved.cir   (ngspice-47, seconds). TEMP 50 as in the golden deck.
* It prints, between BEGIN y and END y, per direction: DIR d, the operating point's currents i(vpb), i(vnb) (A) and then, per frequency, PORT1 / PORT2 with the two printed currents of the
* sources VPB and VNB (A, volts are 1, as in sar_kick_cnode.cir).
.lib $IHP_PDK/ihp-sg13g2/libs.tech/ngspice/models/cornerMOSlv.lib mos_tt
.lib $IHP_PDK/ihp-sg13g2/libs.tech/ngspice/models/cornerCAP.lib cap_typ
.include $SAR_GOLDEN_SUBCKTS
VDD vdd 0 1.5
VCM vcm 0 0.75
VCK ck 0 1.5
VIN vin 0 0.75
VCLK clks 0 0
VST set 0 {vset}
VRS reset 0 {vrst}
XD vdd 0 sar vcm bitp vin ck set reset clks DAC_control
XN vdd 0 ck bitp bitn neg_bottom_plate_logic
VPB bitp 0 {vpb} ac 1
VNB bitn 0 {vnb} ac 0
.param vset=0
.param vrst=0
.param vpb=1.49
.param vnb=0.01
.options temp=50
.control
pre_osdi $IHP_OSDI/psp103.osdi
pre_osdi $IHP_OSDI/psp103_nqs.osdi
set numdgt=8
echo BEGIN y
alterparam vset = 0
alterparam vrst = 1.5
alterparam vpb = 1.49
alterparam vnb = 0.01
reset
op
echo DIR 0
print i(vpb) i(vnb)
foreach fr 1e8 3e8
  alter vpb ac = 1
  alter vnb ac = 0
  ac lin 1 $fr $fr
  echo PORT1 $fr
  print i(vpb) i(vnb)
  alter vpb ac = 0
  alter vnb ac = 1
  ac lin 1 $fr $fr
  echo PORT2 $fr
  print i(vpb) i(vnb)
end
alterparam vset = 1.5
alterparam vrst = 0
alterparam vpb = 0.01
alterparam vnb = 1.49
reset
op
echo DIR 1
print i(vpb) i(vnb)
foreach fr 1e8 3e8
  alter vpb ac = 1
  alter vnb ac = 0
  ac lin 1 $fr $fr
  echo PORT1 $fr
  print i(vpb) i(vnb)
  alter vpb ac = 0
  alter vnb ac = 1
  ac lin 1 $fr $fr
  echo PORT2 $fr
  print i(vpb) i(vnb)
end
echo END y
.endc
.end
