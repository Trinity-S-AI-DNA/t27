M1 3-node RC ladder, backward Euler on a fixed 50 ns grid
* specs/analog/decks/lad3_fixed.cir -- test data for specs/analog/bench.t27 (#10505). A plain netlist, no .control block.
* Circuit: R1, R2, R3 = 1 kOhm in series from IN through nodes 1, 2 and 3; C1, C2, C3 = 1 nF from nodes 1, 2, 3 to
* ground; all capacitors start at 0 V (specs/analog/linear.t27, circuit 3).
* Run: 200 steps of 50 ns, IN = 1 V for the first 100 steps and 0 V for the next 100.
* The grid is made exact as in rc_fixed.cir: a B source declares no breakpoint, the circuit rests at 0 V while the source
* is 0, the source turns on at 425 ns (half a step from the nearest grid point) and turns off at 5425 ns, and from the
* first internal point after 425 ns every step is 50 ns. Step k (k = 0..199) ends at the k-th internal point after 425 ns.
* tstop = 425 ns + 201 steps. gear with maxord 1 is backward Euler; trtol = 1e7 stops the truncation test.
* Run: ngspice -b -r lad3_fixed.raw lad3_fixed.cir   (the raw file holds float64 values)
B1 in 0 V = u(time-425n) - u(time-5425n)
R1 in 1 1k
R2 1 2 1k
R3 2 3 1k
C1 1 0 1n IC=0
C2 2 0 1n IC=0
C3 3 0 1n IC=0
.options method=gear maxord=1 trtol=1e7
.tran 50n 10475n 0 50n uic
.end
