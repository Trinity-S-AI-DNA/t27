SAR ADC dynamic comparator on PSP103 at 27 C with all its charge and the golden bulks: the reference of sar_comparator_q.t27
* specs/analog/decks/sar_cmp_q_ref.cir -- reference data for specs/analog/sar_comparator_q.t27 (analog M4b-q, #11312, epic #10486). A netlist plus a .control block that prints the
* numbers. The circuit is the one of sar_cmp_psp_real.cir (read its header), written out: the thirteen sg13_lv transistors of the golden dynamic_comparator and its inverter, with the
* W, L and m of sar_cmp_psp_r2b.cir (facts of the circuit; the text of the golden deck is not copied and not read), and the bulks as the golden deck has them: every NMOS bulk on ground
* and every PMOS bulk on VDD (r2b ties each bulk to its source instead; the input pair XM3, XM4 and the PMOS XM8, XM9 are the four devices whose source is not at their bulk).
* PSP103 (IHP-Open-PDK 21133f219b1a6da10d803e345761e77415ceff40, cornerMOSlv.lib mos_tt, through OSDI) at 27 C with ALL its charge, 4 fF on dp and dn as the real deck has them, an ideal
* 1.6 ps clock in place of the delay cell, the inputs held. The same netlist at 50 C is sar_cmp_q_ref50.cir, which reproduces sar_cmp_psp_real.cir's decision time of the golden
* subcircuit: that run is the proof that this netlist is that circuit.
* Run: IHP_PDK=<checkout> IHP_OSDI=<osdi dir> ngspice -b sar_cmp_q_ref.cir > sar_cmp_q_ref.out    (ngspice-47; no golden file is read)
* Inputs: VDD 1.5 V, common mode 0.75 V, VDP = 0.75 + sg h / 2^24 and VDN = 0.75 - sg h / 2^24 for h in units of 2^-24 V (h = 16777 is 2h = 33554 units = 2 mV less 0.4 uV), sg = +1 or -1.
* Integration: ngspice's default (trapezoidal), the step capped at 0.5 ps (tstep 0.1 ps, tmax 0.5 ps); reltol 1e-8, vntol 1e-11, abstol 1e-13.
* TWO STARTS, which differ by a transient that is not the circuit's. "RUN S": the SETTLED start, the one the model has: the .ic of the spec's rest (ap = an = net2 = net3 = n_clkc = 1.5 V,
* dp = dn = 0, net1 = 0.4009999632835388 V, max(VDP, VDN) - 0.35 V) WITHOUT uic, so that ngspice first solves the DC operating point with those eight nodes forced and the devices' own
* internal nodes consistent, then releases them; the clock rises at 1 ps. "RUN U": the start of sar_cmp_psp_real.cir, the same .ic WITH uic and the clock at 200 ps: with uic the nodes
* inside the PSP103 devices start at 0 V and their first charging disturbs the external nodes (n_clkc falls to 0.56 V in 10 ps, ap, an, net2 and net3 are kicked above VDD, dp and dn
* rise to 0.9 V), and 200 ps do not settle it (at the clock edge n_clkc is 1.30 V, dp and dn 0.62 V, net1 0.94 V): the decision time of that start is a number of that start. It is
* printed for the record, and the model is judged against the settled start.
* What it prints, per run, after "RUN <start> <h> <sg>": tck, the clock through 0.75 V; tfirst, the first of dp and dn through 0.75 V; tres, |dp - dn| through 0.75 V; dpend and dnend,
* dp and dn at 3 ns. Then, for the +2 mV run of the settled start, "NODES S <t>": the eight nodes ap an net1 net2 net3 dp dn n_clkc at tck + 0, 10, 25, 50, 100, 200, 300, 400, 450, 500, 1000, 1500 and 2000 ps.
* The last block, "RESETRUN", is the +2 mV run of the settled start with the clock FALLING at 2 ns (over 1.6 ps, as it rose): "RESET <t>" prints the eight nodes at 1.9, 2.0, 2.05, 2.1, 2.2, 2.4, 2.8
* and 3.4 ns, the evaluation phase's end and the reset phase.
.lib $IHP_PDK/ihp-sg13g2/libs.tech/ngspice/models/cornerMOSlv.lib mos_tt
Vdd vdd 0 1.5
Vdp vdp 0 0.75
Vdn vdn 0 0.75
.param tclk=200p
.param tfall=1
Bclk clkc 0 V = 1.5*min(max((time-{tclk})/1.6p,0),1)*(1-min(max((time-{tfall})/1.6p,0),1))
XM1 ap clkc vdd vdd sg13_lv_pmos w=3.0u l=0.45u ng=1 m=9
XM2 an clkc vdd vdd sg13_lv_pmos w=3.0u l=0.45u ng=1 m=9
XM3 ap vdn net1 0 sg13_lv_nmos w=1.0u l=0.45u ng=1 m=36
XM4 an vdp net1 0 sg13_lv_nmos w=1.0u l=0.45u ng=1 m=36
XM5 net1 clkc 0 0 sg13_lv_nmos w=1.0u l=0.45u ng=1 m=18
XM6 net2 dp vdd vdd sg13_lv_pmos w=3.0u l=0.45u ng=1 m=30
XM7 net3 dn vdd vdd sg13_lv_pmos w=3.0u l=0.45u ng=1 m=30
XM8 dp an net3 vdd sg13_lv_pmos w=3.0u l=0.45u ng=1 m=30
XM9 dn ap net2 vdd sg13_lv_pmos w=3.0u l=0.45u ng=1 m=30
XM10 dn dp 0 0 sg13_lv_nmos w=1.0u l=0.45u ng=1 m=12
XM11 dp dn 0 0 sg13_lv_nmos w=1.0u l=0.45u ng=1 m=12
XM12 dn n_clkc 0 0 sg13_lv_nmos w=1.0u l=0.45u ng=1 m=6
XM13 dp n_clkc 0 0 sg13_lv_nmos w=1.0u l=0.45u ng=1 m=6
XIP n_clkc clkc vdd vdd sg13_lv_pmos w=3.0u l=0.45u ng=1 m=1
XIN n_clkc clkc 0 0 sg13_lv_nmos w=1.0u l=0.45u ng=1 m=1
Cbdp dp 0 4f
Cbdn dn 0 4f
Bmx mx 0 V = max(v(dp),v(dn))
Bdiff diff 0 V = abs(v(dp)-v(dn))
.ic v(ap)=1.5 v(an)=1.5 v(net1)=0.4009999632835388 v(net2)=1.5 v(net3)=1.5 v(dp)=0 v(dn)=0 v(n_clkc)=1.5
.temp 27
.options reltol=1e-8 vntol=1e-11 abstol=1e-13 itl4=200
.control
set num_threads=2
pre_osdi $IHP_OSDI/psp103.osdi
pre_osdi $IHP_OSDI/psp103_nqs.osdi
set numdgt=10
set noprintscale
alterparam tclk = 1p
reset
foreach h 16777 4194 1049 262 84 8 1
  foreach sg 1 -1
    alter Vdp = 0.75 + $sg * $h / 16777216
    alter Vdn = 0.75 - $sg * $h / 16777216
    tran 0.1p 3n 0 0.5p
    echo RUN S $h $sg
    meas tran tck when v(clkc)=0.75 rise=1
    meas tran tfirst when v(mx)=0.75 rise=1
    meas tran tres when v(diff)=0.75 rise=1
    meas tran dpend find v(dp) at=3n
    meas tran dnend find v(dn) at=3n
  end
end
alter Vdp = 0.75 + 16777 / 16777216
alter Vdn = 0.75 - 16777 / 16777216
tran 0.1p 3n 0 0.5p
meas tran tck when v(clkc)=0.75 rise=1
foreach dtn 0p 10p 25p 50p 100p 200p 300p 400p 450p 500p 1000p 1500p 2000p
  let tt = tck + $dtn
  echo NODES S $dtn
  meas tran vap find v(ap) at=$&tt
  meas tran van find v(an) at=$&tt
  meas tran vn1 find v(net1) at=$&tt
  meas tran vn2 find v(net2) at=$&tt
  meas tran vn3 find v(net3) at=$&tt
  meas tran vdp find v(dp) at=$&tt
  meas tran vdn find v(dn) at=$&tt
  meas tran vnc find v(n_clkc) at=$&tt
end
alterparam tclk = 200p
reset
foreach h 16777 4194
  foreach sg 1 -1
    alter Vdp = 0.75 + $sg * $h / 16777216
    alter Vdn = 0.75 - $sg * $h / 16777216
    tran 0.1p 3n 0 0.5p uic
    echo RUN U $h $sg
    meas tran tck when v(clkc)=0.75 rise=1
    meas tran tfirst when v(mx)=0.75 rise=1
    meas tran tres when v(diff)=0.75 rise=1
    meas tran dpend find v(dp) at=3n
    meas tran dnend find v(dn) at=3n
  end
end
alterparam tclk = 1p
alterparam tfall = 2n
reset
alter Vdp = 0.75 + 16777 / 16777216
alter Vdn = 0.75 - 16777 / 16777216
tran 0.1p 3.5n 0 0.5p
echo RESETRUN
foreach dtn 1900p 2000p 2050p 2100p 2200p 2400p 2800p 3400p
  let tt = $dtn
  echo RESET $dtn
  meas tran vap find v(ap) at=$&tt
  meas tran van find v(an) at=$&tt
  meas tran vn1 find v(net1) at=$&tt
  meas tran vn2 find v(net2) at=$&tt
  meas tran vn3 find v(net3) at=$&tt
  meas tran vdp find v(dp) at=$&tt
  meas tran vdn find v(dn) at=$&tt
  meas tran vnc find v(n_clkc) at=$&tt
end
.endc
.end
