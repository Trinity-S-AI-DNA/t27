SAR clock_gen delay chain history: nor3, delay_cell and inverter of the golden SAR deck driven by Valid pulse trains of many spacings, PSP103 tt at 50 C
* specs/analog/decks/sar_delay_hist.cir -- reference data for specs/analog/sar_logic.t27 (M4d-b, #10848, epic #10486). The delay cell of clock_gen is not a
* settled delay: its input (the nor3 output, a net with 3 pF of long gate) and its output (the net the inverter reads) are still moving when the next Valid
* edge comes, so a delay depends on how long ago the same node last crossed the other way. This deck measures it. Every chain is the clock_gen chain of the
* golden SAR deck (uberWAVE wp2-parser/golden/top.spice, GPL-2.0: fetched at run time, never vendored): nor3(clks = 0, Valid, CK1 = 0) -> delay_cell (trim code
* 000, the golden top's) -> inverter, 8 fF on clkc, each with its own ideal Valid source (the 12 fF of the golden top sit on an ideal source and do not matter).
* Valid starts high (the circuit at rest, n1 low, n2 high), falls at 1.1 ns (the clks fall of the golden run: n1 starts to rise), rises for the first time at
* 49.7 ns (48.6 ns later, as in the golden run) and then in pulses of high time Wh and low time Wl, edges 0.2 ns, all times the 50 % points.
* - c<Wl>l: Wh = 30 ns, Wl = 16 .. 120 ns, four pulses; c<Wh>h: Wl = 30 ns, Wh = 14 .. 120 ns, four pulses. CALIBRATION: sar_logic.t27's history tables
*   (SL_HIST) are read from the fourth pulse of these 21 chains.
* - h01 .. h07: six pulses of other spacings, h01 the golden pace (20.2 / 19.8). HELD OUT: no table entry comes from them.
* - k01: the golden pace with eleven pulses and CK1 (the third input of the nor3) rising 0.654 ns after the eleventh Valid rise and staying up, as in the
*   golden run (sar_logic_ref.cir: CK1 rises 654 ps after the eleventh edge).
* Paths are NOT in this file: ngspice reads IHP_PDK (the IHP-Open-PDK checkout), IHP_OSDI (the directory with the compiled psp103.osdi and psp103_nqs.osdi) and
* SAR_GOLDEN_SUBCKTS (the subcircuit section of the golden deck, made at run time:
*   sed -n '/^.subckt tracking_switch/,$p' top.spice | grep -v -i -E '^\.(end|global)([[:space:]]|$)' > $SAR_GOLDEN_SUBCKTS )  from the environment.
* Run: IHP_PDK=<checkout> IHP_OSDI=<osdi dir> SAR_GOLDEN_SUBCKTS=<file> ngspice -b sar_delay_hist.cir   (ngspice-47)
* It prints one line per crossing at 0.75 V, <name> = <seconds>, name = <chain>_<net><r|f><index>: net n1 (nor3 output), n2 (delay cell output) or ck (clkc), r|f the
* edge, index the count from 1 of that net's edges of that direction. n1 and n2 rise first when Valid first falls (index 1), so after Valid pulse k (from 0) the
* falling edge of n1 is index k + 1 and its rising edge index k + 2; the same for n2 and ck.
.lib $IHP_PDK/ihp-sg13g2/libs.tech/ngspice/models/cornerMOSlv.lib mos_tt
.include $SAR_GOLDEN_SUBCKTS
VDD vdd 0 1.5
Vlo lo 0 0
Vv_c016l v_c016l 0 PWL(0n 1.5 1n 1.5 1.2n 0 49.6n 0 49.8n 1.5 79.6n 1.5 79.8n 0 95.6n 0 95.8n 1.5 125.6n 1.5 125.8n 0 141.6n 0 141.8n 1.5 171.6n 1.5 171.8n 0 187.6n 0 187.8n 1.5 217.6n 1.5 217.8n 0)
xn_c016l vdd 0 n1_c016l lo v_c016l lo nor3
xd_c016l n2_c016l vdd 0 n1_c016l lo lo lo delay_cell
xi_c016l n2_c016l vdd 0 ck_c016l inverter
C_c016l ck_c016l 0 8f
Vv_c018l v_c018l 0 PWL(0n 1.5 1n 1.5 1.2n 0 49.6n 0 49.8n 1.5 79.6n 1.5 79.8n 0 97.6n 0 97.8n 1.5 127.6n 1.5 127.8n 0 145.6n 0 145.8n 1.5 175.6n 1.5 175.8n 0 193.6n 0 193.8n 1.5 223.6n 1.5 223.8n 0)
xn_c018l vdd 0 n1_c018l lo v_c018l lo nor3
xd_c018l n2_c018l vdd 0 n1_c018l lo lo lo delay_cell
xi_c018l n2_c018l vdd 0 ck_c018l inverter
C_c018l ck_c018l 0 8f
Vv_c020l v_c020l 0 PWL(0n 1.5 1n 1.5 1.2n 0 49.6n 0 49.8n 1.5 79.6n 1.5 79.8n 0 99.6n 0 99.8n 1.5 129.6n 1.5 129.8n 0 149.6n 0 149.8n 1.5 179.6n 1.5 179.8n 0 199.6n 0 199.8n 1.5 229.6n 1.5 229.8n 0)
xn_c020l vdd 0 n1_c020l lo v_c020l lo nor3
xd_c020l n2_c020l vdd 0 n1_c020l lo lo lo delay_cell
xi_c020l n2_c020l vdd 0 ck_c020l inverter
C_c020l ck_c020l 0 8f
Vv_c023l v_c023l 0 PWL(0n 1.5 1n 1.5 1.2n 0 49.6n 0 49.8n 1.5 79.6n 1.5 79.8n 0 102.6n 0 102.8n 1.5 132.6n 1.5 132.8n 0 155.6n 0 155.8n 1.5 185.6n 1.5 185.8n 0 208.6n 0 208.8n 1.5 238.6n 1.5 238.8n 0)
xn_c023l vdd 0 n1_c023l lo v_c023l lo nor3
xd_c023l n2_c023l vdd 0 n1_c023l lo lo lo delay_cell
xi_c023l n2_c023l vdd 0 ck_c023l inverter
C_c023l ck_c023l 0 8f
Vv_c027l v_c027l 0 PWL(0n 1.5 1n 1.5 1.2n 0 49.6n 0 49.8n 1.5 79.6n 1.5 79.8n 0 106.6n 0 106.8n 1.5 136.6n 1.5 136.8n 0 163.6n 0 163.8n 1.5 193.6n 1.5 193.8n 0 220.6n 0 220.8n 1.5 250.6n 1.5 250.8n 0)
xn_c027l vdd 0 n1_c027l lo v_c027l lo nor3
xd_c027l n2_c027l vdd 0 n1_c027l lo lo lo delay_cell
xi_c027l n2_c027l vdd 0 ck_c027l inverter
C_c027l ck_c027l 0 8f
Vv_c032l v_c032l 0 PWL(0n 1.5 1n 1.5 1.2n 0 49.6n 0 49.8n 1.5 79.6n 1.5 79.8n 0 111.6n 0 111.8n 1.5 141.6n 1.5 141.8n 0 173.6n 0 173.8n 1.5 203.6n 1.5 203.8n 0 235.6n 0 235.8n 1.5 265.6n 1.5 265.8n 0)
xn_c032l vdd 0 n1_c032l lo v_c032l lo nor3
xd_c032l n2_c032l vdd 0 n1_c032l lo lo lo delay_cell
xi_c032l n2_c032l vdd 0 ck_c032l inverter
C_c032l ck_c032l 0 8f
Vv_c040l v_c040l 0 PWL(0n 1.5 1n 1.5 1.2n 0 49.6n 0 49.8n 1.5 79.6n 1.5 79.8n 0 119.6n 0 119.8n 1.5 149.6n 1.5 149.8n 0 189.6n 0 189.8n 1.5 219.6n 1.5 219.8n 0 259.6n 0 259.8n 1.5 289.6n 1.5 289.8n 0)
xn_c040l vdd 0 n1_c040l lo v_c040l lo nor3
xd_c040l n2_c040l vdd 0 n1_c040l lo lo lo delay_cell
xi_c040l n2_c040l vdd 0 ck_c040l inverter
C_c040l ck_c040l 0 8f
Vv_c055l v_c055l 0 PWL(0n 1.5 1n 1.5 1.2n 0 49.6n 0 49.8n 1.5 79.6n 1.5 79.8n 0 134.6n 0 134.8n 1.5 164.6n 1.5 164.8n 0 219.6n 0 219.8n 1.5 249.6n 1.5 249.8n 0 304.6n 0 304.8n 1.5 334.6n 1.5 334.8n 0)
xn_c055l vdd 0 n1_c055l lo v_c055l lo nor3
xd_c055l n2_c055l vdd 0 n1_c055l lo lo lo delay_cell
xi_c055l n2_c055l vdd 0 ck_c055l inverter
C_c055l ck_c055l 0 8f
Vv_c080l v_c080l 0 PWL(0n 1.5 1n 1.5 1.2n 0 49.6n 0 49.8n 1.5 79.6n 1.5 79.8n 0 159.6n 0 159.8n 1.5 189.6n 1.5 189.8n 0 269.6n 0 269.8n 1.5 299.6n 1.5 299.8n 0 379.6n 0 379.8n 1.5 409.6n 1.5 409.8n 0)
xn_c080l vdd 0 n1_c080l lo v_c080l lo nor3
xd_c080l n2_c080l vdd 0 n1_c080l lo lo lo delay_cell
xi_c080l n2_c080l vdd 0 ck_c080l inverter
C_c080l ck_c080l 0 8f
Vv_c120l v_c120l 0 PWL(0n 1.5 1n 1.5 1.2n 0 49.6n 0 49.8n 1.5 79.6n 1.5 79.8n 0 199.6n 0 199.8n 1.5 229.6n 1.5 229.8n 0 349.6n 0 349.8n 1.5 379.6n 1.5 379.8n 0 499.6n 0 499.8n 1.5 529.6n 1.5 529.8n 0)
xn_c120l vdd 0 n1_c120l lo v_c120l lo nor3
xd_c120l n2_c120l vdd 0 n1_c120l lo lo lo delay_cell
xi_c120l n2_c120l vdd 0 ck_c120l inverter
C_c120l ck_c120l 0 8f
Vv_c014h v_c014h 0 PWL(0n 1.5 1n 1.5 1.2n 0 49.6n 0 49.8n 1.5 63.6n 1.5 63.8n 0 93.6n 0 93.8n 1.5 107.6n 1.5 107.8n 0 137.6n 0 137.8n 1.5 151.6n 1.5 151.8n 0 181.6n 0 181.8n 1.5 195.6n 1.5 195.8n 0)
xn_c014h vdd 0 n1_c014h lo v_c014h lo nor3
xd_c014h n2_c014h vdd 0 n1_c014h lo lo lo delay_cell
xi_c014h n2_c014h vdd 0 ck_c014h inverter
C_c014h ck_c014h 0 8f
Vv_c016h v_c016h 0 PWL(0n 1.5 1n 1.5 1.2n 0 49.6n 0 49.8n 1.5 65.6n 1.5 65.8n 0 95.6n 0 95.8n 1.5 111.6n 1.5 111.8n 0 141.6n 0 141.8n 1.5 157.6n 1.5 157.8n 0 187.6n 0 187.8n 1.5 203.6n 1.5 203.8n 0)
xn_c016h vdd 0 n1_c016h lo v_c016h lo nor3
xd_c016h n2_c016h vdd 0 n1_c016h lo lo lo delay_cell
xi_c016h n2_c016h vdd 0 ck_c016h inverter
C_c016h ck_c016h 0 8f
Vv_c018h v_c018h 0 PWL(0n 1.5 1n 1.5 1.2n 0 49.6n 0 49.8n 1.5 67.6n 1.5 67.8n 0 97.6n 0 97.8n 1.5 115.6n 1.5 115.8n 0 145.6n 0 145.8n 1.5 163.6n 1.5 163.8n 0 193.6n 0 193.8n 1.5 211.6n 1.5 211.8n 0)
xn_c018h vdd 0 n1_c018h lo v_c018h lo nor3
xd_c018h n2_c018h vdd 0 n1_c018h lo lo lo delay_cell
xi_c018h n2_c018h vdd 0 ck_c018h inverter
C_c018h ck_c018h 0 8f
Vv_c020h v_c020h 0 PWL(0n 1.5 1n 1.5 1.2n 0 49.6n 0 49.8n 1.5 69.6n 1.5 69.8n 0 99.6n 0 99.8n 1.5 119.6n 1.5 119.8n 0 149.6n 0 149.8n 1.5 169.6n 1.5 169.8n 0 199.6n 0 199.8n 1.5 219.6n 1.5 219.8n 0)
xn_c020h vdd 0 n1_c020h lo v_c020h lo nor3
xd_c020h n2_c020h vdd 0 n1_c020h lo lo lo delay_cell
xi_c020h n2_c020h vdd 0 ck_c020h inverter
C_c020h ck_c020h 0 8f
Vv_c023h v_c023h 0 PWL(0n 1.5 1n 1.5 1.2n 0 49.6n 0 49.8n 1.5 72.6n 1.5 72.8n 0 102.6n 0 102.8n 1.5 125.6n 1.5 125.8n 0 155.6n 0 155.8n 1.5 178.6n 1.5 178.8n 0 208.6n 0 208.8n 1.5 231.6n 1.5 231.8n 0)
xn_c023h vdd 0 n1_c023h lo v_c023h lo nor3
xd_c023h n2_c023h vdd 0 n1_c023h lo lo lo delay_cell
xi_c023h n2_c023h vdd 0 ck_c023h inverter
C_c023h ck_c023h 0 8f
Vv_c027h v_c027h 0 PWL(0n 1.5 1n 1.5 1.2n 0 49.6n 0 49.8n 1.5 76.6n 1.5 76.8n 0 106.6n 0 106.8n 1.5 133.6n 1.5 133.8n 0 163.6n 0 163.8n 1.5 190.6n 1.5 190.8n 0 220.6n 0 220.8n 1.5 247.6n 1.5 247.8n 0)
xn_c027h vdd 0 n1_c027h lo v_c027h lo nor3
xd_c027h n2_c027h vdd 0 n1_c027h lo lo lo delay_cell
xi_c027h n2_c027h vdd 0 ck_c027h inverter
C_c027h ck_c027h 0 8f
Vv_c032h v_c032h 0 PWL(0n 1.5 1n 1.5 1.2n 0 49.6n 0 49.8n 1.5 81.6n 1.5 81.8n 0 111.6n 0 111.8n 1.5 143.6n 1.5 143.8n 0 173.6n 0 173.8n 1.5 205.6n 1.5 205.8n 0 235.6n 0 235.8n 1.5 267.6n 1.5 267.8n 0)
xn_c032h vdd 0 n1_c032h lo v_c032h lo nor3
xd_c032h n2_c032h vdd 0 n1_c032h lo lo lo delay_cell
xi_c032h n2_c032h vdd 0 ck_c032h inverter
C_c032h ck_c032h 0 8f
Vv_c040h v_c040h 0 PWL(0n 1.5 1n 1.5 1.2n 0 49.6n 0 49.8n 1.5 89.6n 1.5 89.8n 0 119.6n 0 119.8n 1.5 159.6n 1.5 159.8n 0 189.6n 0 189.8n 1.5 229.6n 1.5 229.8n 0 259.6n 0 259.8n 1.5 299.6n 1.5 299.8n 0)
xn_c040h vdd 0 n1_c040h lo v_c040h lo nor3
xd_c040h n2_c040h vdd 0 n1_c040h lo lo lo delay_cell
xi_c040h n2_c040h vdd 0 ck_c040h inverter
C_c040h ck_c040h 0 8f
Vv_c055h v_c055h 0 PWL(0n 1.5 1n 1.5 1.2n 0 49.6n 0 49.8n 1.5 104.6n 1.5 104.8n 0 134.6n 0 134.8n 1.5 189.6n 1.5 189.8n 0 219.6n 0 219.8n 1.5 274.6n 1.5 274.8n 0 304.6n 0 304.8n 1.5 359.6n 1.5 359.8n 0)
xn_c055h vdd 0 n1_c055h lo v_c055h lo nor3
xd_c055h n2_c055h vdd 0 n1_c055h lo lo lo delay_cell
xi_c055h n2_c055h vdd 0 ck_c055h inverter
C_c055h ck_c055h 0 8f
Vv_c080h v_c080h 0 PWL(0n 1.5 1n 1.5 1.2n 0 49.6n 0 49.8n 1.5 129.6n 1.5 129.8n 0 159.6n 0 159.8n 1.5 239.6n 1.5 239.8n 0 269.6n 0 269.8n 1.5 349.6n 1.5 349.8n 0 379.6n 0 379.8n 1.5 459.6n 1.5 459.8n 0)
xn_c080h vdd 0 n1_c080h lo v_c080h lo nor3
xd_c080h n2_c080h vdd 0 n1_c080h lo lo lo delay_cell
xi_c080h n2_c080h vdd 0 ck_c080h inverter
C_c080h ck_c080h 0 8f
Vv_c120h v_c120h 0 PWL(0n 1.5 1n 1.5 1.2n 0 49.6n 0 49.8n 1.5 169.6n 1.5 169.8n 0 199.6n 0 199.8n 1.5 319.6n 1.5 319.8n 0 349.6n 0 349.8n 1.5 469.6n 1.5 469.8n 0 499.6n 0 499.8n 1.5 619.6n 1.5 619.8n 0)
xn_c120h vdd 0 n1_c120h lo v_c120h lo nor3
xd_c120h n2_c120h vdd 0 n1_c120h lo lo lo delay_cell
xi_c120h n2_c120h vdd 0 ck_c120h inverter
C_c120h ck_c120h 0 8f
Vv_h01 v_h01 0 PWL(0n 1.5 1n 1.5 1.2n 0 49.6n 0 49.8n 1.5 69.8n 1.5 70n 0 89.6n 0 89.8n 1.5 109.8n 1.5 110n 0 129.6n 0 129.8n 1.5 149.8n 1.5 150n 0 169.6n 0 169.8n 1.5 189.8n 1.5 190n 0 209.6n 0 209.8n 1.5 229.8n 1.5 230n 0 249.6n 0 249.8n 1.5 269.8n 1.5 270n 0)
xn_h01 vdd 0 n1_h01 lo v_h01 lo nor3
xd_h01 n2_h01 vdd 0 n1_h01 lo lo lo delay_cell
xi_h01 n2_h01 vdd 0 ck_h01 inverter
C_h01 ck_h01 0 8f
Vv_h02 v_h02 0 PWL(0n 1.5 1n 1.5 1.2n 0 49.6n 0 49.8n 1.5 64.6n 1.5 64.8n 0 79.6n 0 79.8n 1.5 94.6n 1.5 94.8n 0 109.6n 0 109.8n 1.5 124.6n 1.5 124.8n 0 139.6n 0 139.8n 1.5 154.6n 1.5 154.8n 0 169.6n 0 169.8n 1.5 184.6n 1.5 184.8n 0 199.6n 0 199.8n 1.5 214.6n 1.5 214.8n 0)
xn_h02 vdd 0 n1_h02 lo v_h02 lo nor3
xd_h02 n2_h02 vdd 0 n1_h02 lo lo lo delay_cell
xi_h02 n2_h02 vdd 0 ck_h02 inverter
C_h02 ck_h02 0 8f
Vv_h03 v_h03 0 PWL(0n 1.5 1n 1.5 1.2n 0 49.6n 0 49.8n 1.5 74.6n 1.5 74.8n 0 99.6n 0 99.8n 1.5 124.6n 1.5 124.8n 0 149.6n 0 149.8n 1.5 174.6n 1.5 174.8n 0 199.6n 0 199.8n 1.5 224.6n 1.5 224.8n 0 249.6n 0 249.8n 1.5 274.6n 1.5 274.8n 0 299.6n 0 299.8n 1.5 324.6n 1.5 324.8n 0)
xn_h03 vdd 0 n1_h03 lo v_h03 lo nor3
xd_h03 n2_h03 vdd 0 n1_h03 lo lo lo delay_cell
xi_h03 n2_h03 vdd 0 ck_h03 inverter
C_h03 ck_h03 0 8f
Vv_h04 v_h04 0 PWL(0n 1.5 1n 1.5 1.2n 0 49.6n 0 49.8n 1.5 67.6n 1.5 67.8n 0 89.6n 0 89.8n 1.5 107.6n 1.5 107.8n 0 129.6n 0 129.8n 1.5 147.6n 1.5 147.8n 0 169.6n 0 169.8n 1.5 187.6n 1.5 187.8n 0 209.6n 0 209.8n 1.5 227.6n 1.5 227.8n 0 249.6n 0 249.8n 1.5 267.6n 1.5 267.8n 0)
xn_h04 vdd 0 n1_h04 lo v_h04 lo nor3
xd_h04 n2_h04 vdd 0 n1_h04 lo lo lo delay_cell
xi_h04 n2_h04 vdd 0 ck_h04 inverter
C_h04 ck_h04 0 8f
Vv_h05 v_h05 0 PWL(0n 1.5 1n 1.5 1.2n 0 49.6n 0 49.8n 1.5 73.6n 1.5 73.8n 0 89.6n 0 89.8n 1.5 113.6n 1.5 113.8n 0 129.6n 0 129.8n 1.5 153.6n 1.5 153.8n 0 169.6n 0 169.8n 1.5 193.6n 1.5 193.8n 0 209.6n 0 209.8n 1.5 233.6n 1.5 233.8n 0 249.6n 0 249.8n 1.5 273.6n 1.5 273.8n 0)
xn_h05 vdd 0 n1_h05 lo v_h05 lo nor3
xd_h05 n2_h05 vdd 0 n1_h05 lo lo lo delay_cell
xi_h05 n2_h05 vdd 0 ck_h05 inverter
C_h05 ck_h05 0 8f
Vv_h06 v_h06 0 PWL(0n 1.5 1n 1.5 1.2n 0 49.6n 0 49.8n 1.5 79.6n 1.5 79.8n 0 99.6n 0 99.8n 1.5 129.6n 1.5 129.8n 0 149.6n 0 149.8n 1.5 179.6n 1.5 179.8n 0 199.6n 0 199.8n 1.5 229.6n 1.5 229.8n 0 249.6n 0 249.8n 1.5 279.6n 1.5 279.8n 0 299.6n 0 299.8n 1.5 329.6n 1.5 329.8n 0)
xn_h06 vdd 0 n1_h06 lo v_h06 lo nor3
xd_h06 n2_h06 vdd 0 n1_h06 lo lo lo delay_cell
xi_h06 n2_h06 vdd 0 ck_h06 inverter
C_h06 ck_h06 0 8f
Vv_h07 v_h07 0 PWL(0n 1.5 1n 1.5 1.2n 0 49.6n 0 49.8n 1.5 71.6n 1.5 71.8n 0 109.6n 0 109.8n 1.5 131.6n 1.5 131.8n 0 169.6n 0 169.8n 1.5 191.6n 1.5 191.8n 0 229.6n 0 229.8n 1.5 251.6n 1.5 251.8n 0 289.6n 0 289.8n 1.5 311.6n 1.5 311.8n 0 349.6n 0 349.8n 1.5 371.6n 1.5 371.8n 0)
xn_h07 vdd 0 n1_h07 lo v_h07 lo nor3
xd_h07 n2_h07 vdd 0 n1_h07 lo lo lo delay_cell
xi_h07 n2_h07 vdd 0 ck_h07 inverter
C_h07 ck_h07 0 8f
Vv_k01 v_k01 0 PWL(0n 1.5 1n 1.5 1.2n 0 49.6n 0 49.8n 1.5 69.8n 1.5 70n 0 89.6n 0 89.8n 1.5 109.8n 1.5 110n 0 129.6n 0 129.8n 1.5 149.8n 1.5 150n 0 169.6n 0 169.8n 1.5 189.8n 1.5 190n 0 209.6n 0 209.8n 1.5 229.8n 1.5 230n 0 249.6n 0 249.8n 1.5 269.8n 1.5 270n 0 289.6n 0 289.8n 1.5 309.8n 1.5 310n 0 329.6n 0 329.8n 1.5 349.8n 1.5 350n 0 369.6n 0 369.8n 1.5 389.8n 1.5 390n 0 409.6n 0 409.8n 1.5 429.8n 1.5 430n 0 449.6n 0 449.8n 1.5 469.8n 1.5 470n 0)
Vc_k01 c_k01 0 PWL(0 0 450.254n 0 450.454n 1.5)
xn_k01 vdd 0 n1_k01 lo v_k01 c_k01 nor3
xd_k01 n2_k01 vdd 0 n1_k01 lo lo lo delay_cell
xi_k01 n2_k01 vdd 0 ck_k01 inverter
C_k01 ck_k01 0 8f
.temp 50
.options reltol=1e-4
.tran 5p 654n 0 50p
.control
option klu
set num_threads=8
pre_osdi $IHP_OSDI/psp103.osdi
pre_osdi $IHP_OSDI/psp103_nqs.osdi
set numdgt=7
run
meas tran c016l_n1f4 when v(n1_c016l)=0.75 fall=4
meas tran c016l_n1r4 when v(n1_c016l)=0.75 rise=4
meas tran c016l_n1r5 when v(n1_c016l)=0.75 rise=5
meas tran c016l_n2r4 when v(n2_c016l)=0.75 rise=4
meas tran c016l_n2f4 when v(n2_c016l)=0.75 fall=4
meas tran c016l_n2f5 when v(n2_c016l)=0.75 fall=5
meas tran c016l_ckf4 when v(ck_c016l)=0.75 fall=4
meas tran c016l_ckr5 when v(ck_c016l)=0.75 rise=5
meas tran c018l_n1f4 when v(n1_c018l)=0.75 fall=4
meas tran c018l_n1r4 when v(n1_c018l)=0.75 rise=4
meas tran c018l_n1r5 when v(n1_c018l)=0.75 rise=5
meas tran c018l_n2r4 when v(n2_c018l)=0.75 rise=4
meas tran c018l_n2f4 when v(n2_c018l)=0.75 fall=4
meas tran c018l_n2f5 when v(n2_c018l)=0.75 fall=5
meas tran c018l_ckf4 when v(ck_c018l)=0.75 fall=4
meas tran c018l_ckr5 when v(ck_c018l)=0.75 rise=5
meas tran c020l_n1f4 when v(n1_c020l)=0.75 fall=4
meas tran c020l_n1r4 when v(n1_c020l)=0.75 rise=4
meas tran c020l_n1r5 when v(n1_c020l)=0.75 rise=5
meas tran c020l_n2r4 when v(n2_c020l)=0.75 rise=4
meas tran c020l_n2f4 when v(n2_c020l)=0.75 fall=4
meas tran c020l_n2f5 when v(n2_c020l)=0.75 fall=5
meas tran c020l_ckf4 when v(ck_c020l)=0.75 fall=4
meas tran c020l_ckr5 when v(ck_c020l)=0.75 rise=5
meas tran c023l_n1f4 when v(n1_c023l)=0.75 fall=4
meas tran c023l_n1r4 when v(n1_c023l)=0.75 rise=4
meas tran c023l_n1r5 when v(n1_c023l)=0.75 rise=5
meas tran c023l_n2r4 when v(n2_c023l)=0.75 rise=4
meas tran c023l_n2f4 when v(n2_c023l)=0.75 fall=4
meas tran c023l_n2f5 when v(n2_c023l)=0.75 fall=5
meas tran c023l_ckf4 when v(ck_c023l)=0.75 fall=4
meas tran c023l_ckr5 when v(ck_c023l)=0.75 rise=5
meas tran c027l_n1f4 when v(n1_c027l)=0.75 fall=4
meas tran c027l_n1r4 when v(n1_c027l)=0.75 rise=4
meas tran c027l_n1r5 when v(n1_c027l)=0.75 rise=5
meas tran c027l_n2r4 when v(n2_c027l)=0.75 rise=4
meas tran c027l_n2f4 when v(n2_c027l)=0.75 fall=4
meas tran c027l_n2f5 when v(n2_c027l)=0.75 fall=5
meas tran c027l_ckf4 when v(ck_c027l)=0.75 fall=4
meas tran c027l_ckr5 when v(ck_c027l)=0.75 rise=5
meas tran c032l_n1f4 when v(n1_c032l)=0.75 fall=4
meas tran c032l_n1r4 when v(n1_c032l)=0.75 rise=4
meas tran c032l_n1r5 when v(n1_c032l)=0.75 rise=5
meas tran c032l_n2r4 when v(n2_c032l)=0.75 rise=4
meas tran c032l_n2f4 when v(n2_c032l)=0.75 fall=4
meas tran c032l_n2f5 when v(n2_c032l)=0.75 fall=5
meas tran c032l_ckf4 when v(ck_c032l)=0.75 fall=4
meas tran c032l_ckr5 when v(ck_c032l)=0.75 rise=5
meas tran c040l_n1f4 when v(n1_c040l)=0.75 fall=4
meas tran c040l_n1r4 when v(n1_c040l)=0.75 rise=4
meas tran c040l_n1r5 when v(n1_c040l)=0.75 rise=5
meas tran c040l_n2r4 when v(n2_c040l)=0.75 rise=4
meas tran c040l_n2f4 when v(n2_c040l)=0.75 fall=4
meas tran c040l_n2f5 when v(n2_c040l)=0.75 fall=5
meas tran c040l_ckf4 when v(ck_c040l)=0.75 fall=4
meas tran c040l_ckr5 when v(ck_c040l)=0.75 rise=5
meas tran c055l_n1f4 when v(n1_c055l)=0.75 fall=4
meas tran c055l_n1r4 when v(n1_c055l)=0.75 rise=4
meas tran c055l_n1r5 when v(n1_c055l)=0.75 rise=5
meas tran c055l_n2r4 when v(n2_c055l)=0.75 rise=4
meas tran c055l_n2f4 when v(n2_c055l)=0.75 fall=4
meas tran c055l_n2f5 when v(n2_c055l)=0.75 fall=5
meas tran c055l_ckf4 when v(ck_c055l)=0.75 fall=4
meas tran c055l_ckr5 when v(ck_c055l)=0.75 rise=5
meas tran c080l_n1f4 when v(n1_c080l)=0.75 fall=4
meas tran c080l_n1r4 when v(n1_c080l)=0.75 rise=4
meas tran c080l_n1r5 when v(n1_c080l)=0.75 rise=5
meas tran c080l_n2r4 when v(n2_c080l)=0.75 rise=4
meas tran c080l_n2f4 when v(n2_c080l)=0.75 fall=4
meas tran c080l_n2f5 when v(n2_c080l)=0.75 fall=5
meas tran c080l_ckf4 when v(ck_c080l)=0.75 fall=4
meas tran c080l_ckr5 when v(ck_c080l)=0.75 rise=5
meas tran c120l_n1f4 when v(n1_c120l)=0.75 fall=4
meas tran c120l_n1r4 when v(n1_c120l)=0.75 rise=4
meas tran c120l_n1r5 when v(n1_c120l)=0.75 rise=5
meas tran c120l_n2r4 when v(n2_c120l)=0.75 rise=4
meas tran c120l_n2f4 when v(n2_c120l)=0.75 fall=4
meas tran c120l_n2f5 when v(n2_c120l)=0.75 fall=5
meas tran c120l_ckf4 when v(ck_c120l)=0.75 fall=4
meas tran c120l_ckr5 when v(ck_c120l)=0.75 rise=5
meas tran c014h_n1f4 when v(n1_c014h)=0.75 fall=4
meas tran c014h_n1r4 when v(n1_c014h)=0.75 rise=4
meas tran c014h_n1r5 when v(n1_c014h)=0.75 rise=5
meas tran c014h_n2r4 when v(n2_c014h)=0.75 rise=4
meas tran c014h_n2f4 when v(n2_c014h)=0.75 fall=4
meas tran c014h_n2f5 when v(n2_c014h)=0.75 fall=5
meas tran c014h_ckf4 when v(ck_c014h)=0.75 fall=4
meas tran c014h_ckr5 when v(ck_c014h)=0.75 rise=5
meas tran c016h_n1f4 when v(n1_c016h)=0.75 fall=4
meas tran c016h_n1r4 when v(n1_c016h)=0.75 rise=4
meas tran c016h_n1r5 when v(n1_c016h)=0.75 rise=5
meas tran c016h_n2r4 when v(n2_c016h)=0.75 rise=4
meas tran c016h_n2f4 when v(n2_c016h)=0.75 fall=4
meas tran c016h_n2f5 when v(n2_c016h)=0.75 fall=5
meas tran c016h_ckf4 when v(ck_c016h)=0.75 fall=4
meas tran c016h_ckr5 when v(ck_c016h)=0.75 rise=5
meas tran c018h_n1f4 when v(n1_c018h)=0.75 fall=4
meas tran c018h_n1r4 when v(n1_c018h)=0.75 rise=4
meas tran c018h_n1r5 when v(n1_c018h)=0.75 rise=5
meas tran c018h_n2r4 when v(n2_c018h)=0.75 rise=4
meas tran c018h_n2f4 when v(n2_c018h)=0.75 fall=4
meas tran c018h_n2f5 when v(n2_c018h)=0.75 fall=5
meas tran c018h_ckf4 when v(ck_c018h)=0.75 fall=4
meas tran c018h_ckr5 when v(ck_c018h)=0.75 rise=5
meas tran c020h_n1f4 when v(n1_c020h)=0.75 fall=4
meas tran c020h_n1r4 when v(n1_c020h)=0.75 rise=4
meas tran c020h_n1r5 when v(n1_c020h)=0.75 rise=5
meas tran c020h_n2r4 when v(n2_c020h)=0.75 rise=4
meas tran c020h_n2f4 when v(n2_c020h)=0.75 fall=4
meas tran c020h_n2f5 when v(n2_c020h)=0.75 fall=5
meas tran c020h_ckf4 when v(ck_c020h)=0.75 fall=4
meas tran c020h_ckr5 when v(ck_c020h)=0.75 rise=5
meas tran c023h_n1f4 when v(n1_c023h)=0.75 fall=4
meas tran c023h_n1r4 when v(n1_c023h)=0.75 rise=4
meas tran c023h_n1r5 when v(n1_c023h)=0.75 rise=5
meas tran c023h_n2r4 when v(n2_c023h)=0.75 rise=4
meas tran c023h_n2f4 when v(n2_c023h)=0.75 fall=4
meas tran c023h_n2f5 when v(n2_c023h)=0.75 fall=5
meas tran c023h_ckf4 when v(ck_c023h)=0.75 fall=4
meas tran c023h_ckr5 when v(ck_c023h)=0.75 rise=5
meas tran c027h_n1f4 when v(n1_c027h)=0.75 fall=4
meas tran c027h_n1r4 when v(n1_c027h)=0.75 rise=4
meas tran c027h_n1r5 when v(n1_c027h)=0.75 rise=5
meas tran c027h_n2r4 when v(n2_c027h)=0.75 rise=4
meas tran c027h_n2f4 when v(n2_c027h)=0.75 fall=4
meas tran c027h_n2f5 when v(n2_c027h)=0.75 fall=5
meas tran c027h_ckf4 when v(ck_c027h)=0.75 fall=4
meas tran c027h_ckr5 when v(ck_c027h)=0.75 rise=5
meas tran c032h_n1f4 when v(n1_c032h)=0.75 fall=4
meas tran c032h_n1r4 when v(n1_c032h)=0.75 rise=4
meas tran c032h_n1r5 when v(n1_c032h)=0.75 rise=5
meas tran c032h_n2r4 when v(n2_c032h)=0.75 rise=4
meas tran c032h_n2f4 when v(n2_c032h)=0.75 fall=4
meas tran c032h_n2f5 when v(n2_c032h)=0.75 fall=5
meas tran c032h_ckf4 when v(ck_c032h)=0.75 fall=4
meas tran c032h_ckr5 when v(ck_c032h)=0.75 rise=5
meas tran c040h_n1f4 when v(n1_c040h)=0.75 fall=4
meas tran c040h_n1r4 when v(n1_c040h)=0.75 rise=4
meas tran c040h_n1r5 when v(n1_c040h)=0.75 rise=5
meas tran c040h_n2r4 when v(n2_c040h)=0.75 rise=4
meas tran c040h_n2f4 when v(n2_c040h)=0.75 fall=4
meas tran c040h_n2f5 when v(n2_c040h)=0.75 fall=5
meas tran c040h_ckf4 when v(ck_c040h)=0.75 fall=4
meas tran c040h_ckr5 when v(ck_c040h)=0.75 rise=5
meas tran c055h_n1f4 when v(n1_c055h)=0.75 fall=4
meas tran c055h_n1r4 when v(n1_c055h)=0.75 rise=4
meas tran c055h_n1r5 when v(n1_c055h)=0.75 rise=5
meas tran c055h_n2r4 when v(n2_c055h)=0.75 rise=4
meas tran c055h_n2f4 when v(n2_c055h)=0.75 fall=4
meas tran c055h_n2f5 when v(n2_c055h)=0.75 fall=5
meas tran c055h_ckf4 when v(ck_c055h)=0.75 fall=4
meas tran c055h_ckr5 when v(ck_c055h)=0.75 rise=5
meas tran c080h_n1f4 when v(n1_c080h)=0.75 fall=4
meas tran c080h_n1r4 when v(n1_c080h)=0.75 rise=4
meas tran c080h_n1r5 when v(n1_c080h)=0.75 rise=5
meas tran c080h_n2r4 when v(n2_c080h)=0.75 rise=4
meas tran c080h_n2f4 when v(n2_c080h)=0.75 fall=4
meas tran c080h_n2f5 when v(n2_c080h)=0.75 fall=5
meas tran c080h_ckf4 when v(ck_c080h)=0.75 fall=4
meas tran c080h_ckr5 when v(ck_c080h)=0.75 rise=5
meas tran c120h_n1f4 when v(n1_c120h)=0.75 fall=4
meas tran c120h_n1r4 when v(n1_c120h)=0.75 rise=4
meas tran c120h_n1r5 when v(n1_c120h)=0.75 rise=5
meas tran c120h_n2r4 when v(n2_c120h)=0.75 rise=4
meas tran c120h_n2f4 when v(n2_c120h)=0.75 fall=4
meas tran c120h_n2f5 when v(n2_c120h)=0.75 fall=5
meas tran c120h_ckf4 when v(ck_c120h)=0.75 fall=4
meas tran c120h_ckr5 when v(ck_c120h)=0.75 rise=5
meas tran h01_ckf1 when v(ck_h01)=0.75 fall=1
meas tran h01_ckf2 when v(ck_h01)=0.75 fall=2
meas tran h01_ckf3 when v(ck_h01)=0.75 fall=3
meas tran h01_ckf4 when v(ck_h01)=0.75 fall=4
meas tran h01_ckf5 when v(ck_h01)=0.75 fall=5
meas tran h01_ckf6 when v(ck_h01)=0.75 fall=6
meas tran h01_ckr2 when v(ck_h01)=0.75 rise=2
meas tran h01_ckr3 when v(ck_h01)=0.75 rise=3
meas tran h01_ckr4 when v(ck_h01)=0.75 rise=4
meas tran h01_ckr5 when v(ck_h01)=0.75 rise=5
meas tran h01_ckr6 when v(ck_h01)=0.75 rise=6
meas tran h01_ckr7 when v(ck_h01)=0.75 rise=7
meas tran h02_ckf1 when v(ck_h02)=0.75 fall=1
meas tran h02_ckf2 when v(ck_h02)=0.75 fall=2
meas tran h02_ckf3 when v(ck_h02)=0.75 fall=3
meas tran h02_ckf4 when v(ck_h02)=0.75 fall=4
meas tran h02_ckf5 when v(ck_h02)=0.75 fall=5
meas tran h02_ckf6 when v(ck_h02)=0.75 fall=6
meas tran h02_ckr2 when v(ck_h02)=0.75 rise=2
meas tran h02_ckr3 when v(ck_h02)=0.75 rise=3
meas tran h02_ckr4 when v(ck_h02)=0.75 rise=4
meas tran h02_ckr5 when v(ck_h02)=0.75 rise=5
meas tran h02_ckr6 when v(ck_h02)=0.75 rise=6
meas tran h02_ckr7 when v(ck_h02)=0.75 rise=7
meas tran h03_ckf1 when v(ck_h03)=0.75 fall=1
meas tran h03_ckf2 when v(ck_h03)=0.75 fall=2
meas tran h03_ckf3 when v(ck_h03)=0.75 fall=3
meas tran h03_ckf4 when v(ck_h03)=0.75 fall=4
meas tran h03_ckf5 when v(ck_h03)=0.75 fall=5
meas tran h03_ckf6 when v(ck_h03)=0.75 fall=6
meas tran h03_ckr2 when v(ck_h03)=0.75 rise=2
meas tran h03_ckr3 when v(ck_h03)=0.75 rise=3
meas tran h03_ckr4 when v(ck_h03)=0.75 rise=4
meas tran h03_ckr5 when v(ck_h03)=0.75 rise=5
meas tran h03_ckr6 when v(ck_h03)=0.75 rise=6
meas tran h03_ckr7 when v(ck_h03)=0.75 rise=7
meas tran h04_ckf1 when v(ck_h04)=0.75 fall=1
meas tran h04_ckf2 when v(ck_h04)=0.75 fall=2
meas tran h04_ckf3 when v(ck_h04)=0.75 fall=3
meas tran h04_ckf4 when v(ck_h04)=0.75 fall=4
meas tran h04_ckf5 when v(ck_h04)=0.75 fall=5
meas tran h04_ckf6 when v(ck_h04)=0.75 fall=6
meas tran h04_ckr2 when v(ck_h04)=0.75 rise=2
meas tran h04_ckr3 when v(ck_h04)=0.75 rise=3
meas tran h04_ckr4 when v(ck_h04)=0.75 rise=4
meas tran h04_ckr5 when v(ck_h04)=0.75 rise=5
meas tran h04_ckr6 when v(ck_h04)=0.75 rise=6
meas tran h04_ckr7 when v(ck_h04)=0.75 rise=7
meas tran h05_ckf1 when v(ck_h05)=0.75 fall=1
meas tran h05_ckf2 when v(ck_h05)=0.75 fall=2
meas tran h05_ckf3 when v(ck_h05)=0.75 fall=3
meas tran h05_ckf4 when v(ck_h05)=0.75 fall=4
meas tran h05_ckf5 when v(ck_h05)=0.75 fall=5
meas tran h05_ckf6 when v(ck_h05)=0.75 fall=6
meas tran h05_ckr2 when v(ck_h05)=0.75 rise=2
meas tran h05_ckr3 when v(ck_h05)=0.75 rise=3
meas tran h05_ckr4 when v(ck_h05)=0.75 rise=4
meas tran h05_ckr5 when v(ck_h05)=0.75 rise=5
meas tran h05_ckr6 when v(ck_h05)=0.75 rise=6
meas tran h05_ckr7 when v(ck_h05)=0.75 rise=7
meas tran h06_ckf1 when v(ck_h06)=0.75 fall=1
meas tran h06_ckf2 when v(ck_h06)=0.75 fall=2
meas tran h06_ckf3 when v(ck_h06)=0.75 fall=3
meas tran h06_ckf4 when v(ck_h06)=0.75 fall=4
meas tran h06_ckf5 when v(ck_h06)=0.75 fall=5
meas tran h06_ckf6 when v(ck_h06)=0.75 fall=6
meas tran h06_ckr2 when v(ck_h06)=0.75 rise=2
meas tran h06_ckr3 when v(ck_h06)=0.75 rise=3
meas tran h06_ckr4 when v(ck_h06)=0.75 rise=4
meas tran h06_ckr5 when v(ck_h06)=0.75 rise=5
meas tran h06_ckr6 when v(ck_h06)=0.75 rise=6
meas tran h06_ckr7 when v(ck_h06)=0.75 rise=7
meas tran h07_ckf1 when v(ck_h07)=0.75 fall=1
meas tran h07_ckf2 when v(ck_h07)=0.75 fall=2
meas tran h07_ckf3 when v(ck_h07)=0.75 fall=3
meas tran h07_ckf4 when v(ck_h07)=0.75 fall=4
meas tran h07_ckf5 when v(ck_h07)=0.75 fall=5
meas tran h07_ckf6 when v(ck_h07)=0.75 fall=6
meas tran h07_ckr2 when v(ck_h07)=0.75 rise=2
meas tran h07_ckr3 when v(ck_h07)=0.75 rise=3
meas tran h07_ckr4 when v(ck_h07)=0.75 rise=4
meas tran h07_ckr5 when v(ck_h07)=0.75 rise=5
meas tran h07_ckr6 when v(ck_h07)=0.75 rise=6
meas tran h07_ckr7 when v(ck_h07)=0.75 rise=7
meas tran k01_ckf10 when v(ck_k01)=0.75 fall=10
meas tran k01_ckf11 when v(ck_k01)=0.75 fall=11
meas tran k01_n1f11 when v(n1_k01)=0.75 fall=11
meas tran k01_n2r11 when v(n2_k01)=0.75 rise=11
.endc
.end
