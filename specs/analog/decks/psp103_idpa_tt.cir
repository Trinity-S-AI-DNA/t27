IHP SG13G2 PSP103 log-domain current tables, corner mos_tt
* specs/analog/decks/psp103_idpa_tt.cir -- the log-domain current tables for specs/analog/mos_psp103_data.t27 (M3c-2, #10881, epic #10486), the weak-inversion-accurate
* read of mos_table.t27. A netlist plus a .control block that prints the numbers.
* Model: IHP-Open-PDK commit 21133f219b1a6da10d803e345761e77415ceff40, ihp-sg13g2/libs.tech/ngspice/models/cornerMOSlv.lib (PSP 103.6, revision 200310), section
* mos_tt; the model code is libs.tech/verilog-a/psp103/psp103.va of the same commit, compiled with OpenVAF-Reloaded v24.0.2mob to psp103.osdi (and psp103_nqs.osdi).
* Temperature 27 C (TNOM 27 C). Devices: sg13_lv_nmos w=1.0u l=0.45u ng=1 m=1 and sg13_lv_pmos w=3.0u l=0.45u ng=1 m=1, exactly the devices of psp103_tab_tt.cir (the same
* netlist lines).
* Solver options: reltol 1e-6, vntol 1e-9, abstol 1e-14, as psp103_tab_tt.cir.
* Paths are NOT in this file. ngspice reads two environment variables: IHP_PDK, the IHP-Open-PDK checkout, and IHP_OSDI, the directory that holds the compiled
* psp103.osdi and psp103_nqs.osdi.
* Run: IHP_PDK=<checkout> IHP_OSDI=<osdi dir> ngspice -b psp103_idpa_tt.cir > psp103_idpa_tt.out    (ngspice-47)
* THE TABLE. A node is the drain current Id, divided by the factor of weak inversion F = 1 - exp(-Vds / s(Vgs)), as log2 in 1/65536 of an octave, relative to
* IUNIT = 1 / (200 * 2^32) A = 1.164 pA (one table word of the linear tables, 298 pA, over 256). With the gate scale
*     s(Vgs) = sqrt(0.030^2 + (0.65 * max(Vgs - 0.23, 0))^2)  volts,     rv = nint(4096 / s)  (the word the reader multiplies Vds by),   s_eff = 4096 / rv,
* the word of node (ix, iy), Vgs = ix * 15.625 mV (ix = 0 .. 96), Vds = iy * 31.25 mV (iy = 0 .. 48), is
*     iy >= 1:  nint(65536 * log2(max(Id / F(Vds; s_eff), IUNIT) / IUNIT))
*     iy  = 0:  nint(65536 * log2(max(s_eff * gds0, IUNIT) / IUNIT))     gds0 = the output conductance ngspice reports at Vds = 0, the limit of Id / F there.
* Index ix * 49 + iy, ix outer, 4753 rows. The PMOS is read at Vsg = 1.5 V - Vgp and Vsd = 1.5 V - Vdp, source and bulk on the 1.5 V rail, the same words.
* What it prints. Between "BEGIN name" and "END name" every row "<index> TAB <value>" is one number, in sweep order (the first sweep source runs fastest).
* The values are pasted into the spec in that order, none changed.
*   lam_n, lam_p  the 4753 words of the NMOS and of the PMOS (as above);   r_n, r_p  rv at Vgs = ix * 15.625 mV, 97 rows each.
*   cen_n, cen_p  Id in pA (nint(Id * 1e12)) at 1000 held-out points that are CENTRES of cells of this grid, the places a chord of it is worst: point k = 1..1000 is
*           Vgs (Vsg) = (floor(96 frac(k a1)) + 1/2) * 15.625 mV and Vds (Vsd) = (floor(48 frac(k a2)) + 1/2) * 31.25 mV, a1 = 0.7548776662466927, a2 = 0.5698402909980532.
* nmos table device: drain VDN, gate VGN, source and bulk at 0 V
.lib $IHP_PDK/ihp-sg13g2/libs.tech/ngspice/models/cornerMOSlv.lib mos_tt
VDN dn 0 0
VGN gn 0 0
XMN dn gn 0 0 sg13_lv_nmos w=1.0u l=0.45u ng=1 m=1
* pmos table device: source and bulk at the 1.5 V rail, drain VDP and gate VGP, both swept downward from 1.5 V
VSP sp 0 1.5
VDP dp 0 1.5
VGP gp 0 1.5
XMP dp gp sp sp sg13_lv_pmos w=3.0u l=0.45u ng=1 m=1
* held-out points: B sources compute the cell centre from the sweep variable k; the zero-volt sources VRDN, VRDP measure the drain current
VK k 0 1
BRGN rgn 0 V = (floor(96*(v(k)*0.7548776662466927-floor(v(k)*0.7548776662466927)))+0.5)*0.015625
BRDN rdn0 0 V = (floor(48*(v(k)*0.5698402909980532-floor(v(k)*0.5698402909980532)))+0.5)*0.03125
VRDN rdn0 rdn 0
XRN rdn rgn 0 0 sg13_lv_nmos w=1.0u l=0.45u ng=1 m=1
BRGP rgp 0 V = 1.5-(floor(96*(v(k)*0.7548776662466927-floor(v(k)*0.7548776662466927)))+0.5)*0.015625
BRDP rdp0 0 V = 1.5-(floor(48*(v(k)*0.5698402909980532-floor(v(k)*0.5698402909980532)))+0.5)*0.03125
VRDP rdp rdp0 0
VRSP rsp 0 1.5
XRP rdp rgp rsp rsp sg13_lv_pmos w=3.0u l=0.45u ng=1 m=1
.temp 27
.options reltol=1e-6 vntol=1e-9 abstol=1e-14
.control
pre_osdi $IHP_OSDI/psp103.osdi
pre_osdi $IHP_OSDI/psp103_nqs.osdi
set numdgt=10
set noprintscale
save all @n.xmn.nsg13_lv_nmos[gds] @n.xmp.nsg13_lv_pmos[gds]
* the output conductance at Vds = 0 at the 97 gate nodes, and the gate scale and its word there (the same for both devices); plots dc1 (nmos) and dc2 (pmos)
alter VDN = 0
dc VGN 0 1.5 0.015625
let gzn = @n.xmn.nsg13_lv_nmos[gds]
let kk = vector(97)
let vgk = kk * 0.015625
let ovk = (vgk - 0.23 + abs(vgk - 0.23)) / 2
let sk = sqrt(0.03 * 0.03 + 0.65 * 0.65 * ovk * ovk)
let rk = nint(4096 / sk)
let sek = 4096 / rk
let an = gzn * sek
let zn = (an + 1.1641532182693481e-12 + abs(an - 1.1641532182693481e-12)) / 2
let l0n = nint(65536 / ln(2) * ln(zn / 1.1641532182693481e-12))
alter VDP = 1.5
dc VGP 1.5 0 -0.015625
let gzp = @n.xmp.nsg13_lv_pmos[gds]
let kk = vector(97)
let vgk = kk * 0.015625
let ovk = (vgk - 0.23 + abs(vgk - 0.23)) / 2
let sk = sqrt(0.03 * 0.03 + 0.65 * 0.65 * ovk * ovk)
let rk = nint(4096 / sk)
let sek = 4096 / rk
let ap = gzp * sek
let zp = (ap + 1.1641532182693481e-12 + abs(ap - 1.1641532182693481e-12)) / 2
let l0p = nint(65536 / ln(2) * ln(zp / 1.1641532182693481e-12))
echo BEGIN r_n
print rk
echo END r_n
echo BEGIN r_p
print rk
echo END r_p
* the NMOS grid
alter VDN = 0
dc VDN 0 1.5 0.03125 VGN 0 1.5 0.015625
let vgn = v(gn)
let vdn = v(dn)
let ovn = (vgn - 0.23 + abs(vgn - 0.23)) / 2
let sn = sqrt(0.03 * 0.03 + 0.65 * 0.65 * ovn * ovn)
let rn = nint(4096 / sn)
let fn = 1 - exp(0 - vdn * rn / 4096)
let idn = 0 - i(VDN)
let qn = (idn + abs(idn)) / 2
let jn = qn / (fn + 1e-30)
let mn = (jn + 1.1641532182693481e-12 + abs(jn - 1.1641532182693481e-12)) / 2
let lamn = nint(65536 / ln(2) * ln(mn / 1.1641532182693481e-12))
let k = 0
while k < 97
  let lamn[k*49] = dc1.l0n[k]
  let k = k + 1
end
echo BEGIN lam_n
print lamn
echo END lam_n
* the PMOS grid
alter VDP = 1.5
dc VDP 1.5 0 -0.03125 VGP 1.5 0 -0.015625
let vgp = 1.5 - v(gp)
let vdp = 1.5 - v(dp)
let ovp = (vgp - 0.23 + abs(vgp - 0.23)) / 2
let sp = sqrt(0.03 * 0.03 + 0.65 * 0.65 * ovp * ovp)
let rp = nint(4096 / sp)
let fp = 1 - exp(0 - vdp * rp / 4096)
let idp = i(VDP)
let qp = (idp + abs(idp)) / 2
let jp = qp / (fp + 1e-30)
let mp = (jp + 1.1641532182693481e-12 + abs(jp - 1.1641532182693481e-12)) / 2
let lamp = nint(65536 / ln(2) * ln(mp / 1.1641532182693481e-12))
let k = 0
while k < 97
  let lamp[k*49] = dc2.l0p[k]
  let k = k + 1
end
echo BEGIN lam_p
print lamp
echo END lam_p
echo BEGIN cen_n
dc VK 1 1000 1
let u = nint(i(VRDN) * 1e12)
print u
echo END cen_n
echo BEGIN cen_p
let u = nint(i(VRDP) * 1e12)
print u
echo END cen_p
.endc
.end
