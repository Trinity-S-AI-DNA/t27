IHP SG13G2 PSP103 log-domain current tables with a source-to-bulk axis, corner mos_tt
* specs/analog/decks/psp103_idpa_vsb_tt.cir -- the log-domain current tables of the tt corner at seven source-to-bulk voltages Vsb = 0, 0.25, .. 1.5 V, for
* specs/analog/mos_psp103_vsb_data.t27 (M3e, #11283, epic #10486): psp103_idpa_tt.cir with the bulk of each device moved off its source. A netlist plus a .control block that prints the numbers.
* Model: IHP-Open-PDK commit 21133f219b1a6da10d803e345761e77415ceff40, ihp-sg13g2/libs.tech/ngspice/models/cornerMOSlv.lib (PSP 103.6, revision 200310), section
* mos_tt; the model code is libs.tech/verilog-a/psp103/psp103.va of the same commit, compiled with OpenVAF-Reloaded v24.0.2mob to psp103.osdi (and psp103_nqs.osdi).
* Temperature 27 C (TNOM 27 C). Devices: sg13_lv_nmos w=1.0u l=0.45u ng=1 m=1 and sg13_lv_pmos w=3.0u l=0.45u ng=1 m=1, the devices of psp103_idpa_tt.cir (the same netlist lines
* but for the bulk terminal).
* Solver options: reltol 1e-6, vntol 1e-9, abstol 1e-14, as psp103_idpa_tt.cir.
* Paths are NOT in this file. ngspice reads two environment variables: IHP_PDK, the IHP-Open-PDK checkout, and IHP_OSDI, the directory that holds the compiled
* psp103.osdi and psp103_nqs.osdi.
* Run: IHP_PDK=<checkout> IHP_OSDI=<osdi dir> ngspice -b psp103_idpa_vsb_tt.cir > psp103_idpa_vsb_tt.out    (ngspice-47)
* WHY. The tables of psp103_idpa_tt.cir have each bulk tied to its source (the NMOS source and bulk at 0 V, the PMOS source and bulk at 1.5 V), so they hold no body effect, and a
* transmission gate whose bulks sit on the rails (the NMOS bulk at 0 V, the PMOS bulk at 1.5 V) has a source above (NMOS) or below (PMOS) its bulk while it conducts. accept_tgate.cir
* measured it: the cell with its bulks on the rails is 30 percent above the cell with each bulk tied to its source. This deck adds the missing axis.
* THE AXIS. Vsb is the reverse bias of the source-to-bulk junction, a magnitude for both devices: the NMOS bulk is at -Vsb (its source at 0 V), the PMOS bulk is at 1.5 V + Vsb (its
* source at the 1.5 V rail). A model is a function of voltage differences, so this is the same device as one whose source is at any other level and whose bulk is Vsb below it (NMOS)
* or above it (PMOS), which is how the tgate's devices sit. Vsb = k * 0.25 V, k = 0 .. 6 (7 slices); the slice k = 0 is psp103_idpa_tt.cir's table again (bulk on the source, written as a node of its own): it agrees with TT_LG_N and TT_LG_P of mos_psp103_data.t27 in all but 4 and 3 of 4753 words, by at most 3 words, the solver noise of two netlists at reltol 1e-6, and the spec takes the existing tables for it.
* THE TABLE of each slice is psp103_idpa_tt.cir's, the same grid and the same integer encoding. A node is the drain current Id, divided by the factor of weak inversion
* F = 1 - exp(-Vds / s(Vgs)), as log2 in 1/65536 of an octave, relative to IUNIT = 1 / (200 * 2^32) A = 1.164 pA. With the gate scale (the tt one, the same at every Vsb: the reader
* multiplies Vds by rv, which depends on Vgs only)
*     s(Vgs) = sqrt(0.030^2 + (0.65 * max(Vgs - 0.23, 0))^2)  volts,     rv = nint(4096 / s)  (the word the reader multiplies Vds by),   s_eff = 4096 / rv,
* the word of node (ix, iy), Vgs = ix * 15.625 mV (ix = 0 .. 96), Vds = iy * 31.25 mV (iy = 0 .. 48), is
*     iy >= 1:  nint(65536 * log2(max(Id / F(Vds; s_eff), IUNIT) / IUNIT))
*     iy  = 0:  nint(65536 * log2(max(s_eff * gds0, IUNIT) / IUNIT))     gds0 = the output conductance ngspice reports at Vds = 0, the limit of Id / F there.
* Index ix * 49 + iy, ix outer, 4753 rows. The PMOS is read at Vsg = 1.5 V - Vgp and Vsd = 1.5 V - Vdp.
* What it prints. Between "BEGIN name" and "END name" every row "<index> TAB <value>" is one number, in sweep order (the first sweep source runs fastest). The values are pasted into
* the spec in that order, none changed.
*   lam_n_k, lam_p_k   the 4753 words of the NMOS and of the PMOS at Vsb = k * 0.25 V, k = 0 .. 6;   r_k   rv at Vgs = ix * 15.625 mV, 97 rows (the same for both devices, and for every k).
*   cen_n, cen_p       Id in pA (nint(Id * 1e12)) at 1000 held-out points that are CENTRES of cells of the (Vgs, Vds, Vsb) grid, the places a chord of it is worst: point k = 1..1000 is
*           Vgs (Vsg) = (floor(96 frac(k a1)) + 1/2) * 15.625 mV, Vds (Vsd) = (floor(48 frac(k a2)) + 1/2) * 31.25 mV and Vsb = (floor(6 frac(k a3)) + 1/2) * 0.25 V (so Vsb is
*           halfway between two slices: 0.125, 0.375, .. 1.375 V), with a1 = 0.8191725133961645, a2 = 0.6710436067037893, a3 = 0.5497004779019703 (the 3-D R sequence, 1/g, 1/g^2, 1/g^3 for g^4 = g + 1).
* nmos table device: drain VDN, gate VGN, source at 0 V, bulk VBN at -Vsb
.lib $IHP_PDK/ihp-sg13g2/libs.tech/ngspice/models/cornerMOSlv.lib mos_tt
VDN dn 0 0
VGN gn 0 0
VBN bn 0 0
XMN dn gn 0 bn sg13_lv_nmos w=1.0u l=0.45u ng=1 m=1
* pmos table device: source at the 1.5 V rail, bulk VBP at 1.5 V + Vsb, drain VDP and gate VGP, both swept downward from 1.5 V
VSP sp 0 1.5
VDP dp 0 1.5
VGP gp 0 1.5
VBP bp 0 1.5
XMP dp gp sp bp sg13_lv_pmos w=3.0u l=0.45u ng=1 m=1
* held-out points: B sources compute the cell centre from the sweep variable k; the zero-volt sources VRDN, VRDP measure the drain current
VK k 0 1
BRGN rgn 0 V = (floor(96*(v(k)*0.8191725133961645-floor(v(k)*0.8191725133961645)))+0.5)*0.015625
BRDN rdn0 0 V = (floor(48*(v(k)*0.6710436067037893-floor(v(k)*0.6710436067037893)))+0.5)*0.03125
BRBN rbn 0 V = 0-(floor(6*(v(k)*0.5497004779019703-floor(v(k)*0.5497004779019703)))+0.5)*0.25
VRDN rdn0 rdn 0
XRN rdn rgn 0 rbn sg13_lv_nmos w=1.0u l=0.45u ng=1 m=1
BRGP rgp 0 V = 1.5-(floor(96*(v(k)*0.8191725133961645-floor(v(k)*0.8191725133961645)))+0.5)*0.015625
BRDP rdp0 0 V = 1.5-(floor(48*(v(k)*0.6710436067037893-floor(v(k)*0.6710436067037893)))+0.5)*0.03125
BRBP rbp 0 V = 1.5+(floor(6*(v(k)*0.5497004779019703-floor(v(k)*0.5497004779019703)))+0.5)*0.25
VRDP rdp rdp0 0
VRSP rsp 0 1.5
XRP rdp rgp rsp rbp sg13_lv_pmos w=3.0u l=0.45u ng=1 m=1
.temp 27
.options reltol=1e-6 vntol=1e-9 abstol=1e-14
.control
pre_osdi $IHP_OSDI/psp103.osdi
pre_osdi $IHP_OSDI/psp103_nqs.osdi
set num_threads=2
set numdgt=10
set noprintscale
save all @n.xmn.nsg13_lv_nmos[gds] @n.xmp.nsg13_lv_pmos[gds]
* ---- slice 0: Vsb = 0 V (the NMOS bulk at 0 V, the PMOS bulk at 1.5 V). Plots dc1, dc2: the Vds = 0 columns; dc3, dc4: the grids.
alter VBN = 0
alter VBP = 1.5
alter VDN = 0
dc VGN 0 1.5 0.015625
let gzn = @n.xmn.nsg13_lv_nmos[gds]
let kk = vector(97)
let vgk = kk * 0.015625
let ovk = (vgk - 0.23 + abs(vgk - 0.23)) / 2
let sk = sqrt(0.03 * 0.03 + 0.65 * 0.65 * ovk * ovk)
let rk = nint(4096 / sk)
let sek = 4096 / rk
let an = gzn * sek
let zn = (an + 1.1641532182693481e-12 + abs(an - 1.1641532182693481e-12)) / 2
let l0n = nint(65536 / ln(2) * ln(zn / 1.1641532182693481e-12))
alter VDP = 1.5
dc VGP 1.5 0 -0.015625
let gzp = @n.xmp.nsg13_lv_pmos[gds]
let kk = vector(97)
let vgk = kk * 0.015625
let ovk = (vgk - 0.23 + abs(vgk - 0.23)) / 2
let sk = sqrt(0.03 * 0.03 + 0.65 * 0.65 * ovk * ovk)
let rk = nint(4096 / sk)
let sek = 4096 / rk
let ap = gzp * sek
let zp = (ap + 1.1641532182693481e-12 + abs(ap - 1.1641532182693481e-12)) / 2
let l0p = nint(65536 / ln(2) * ln(zp / 1.1641532182693481e-12))
echo BEGIN r_0
print rk
echo END r_0
alter VDN = 0
dc VDN 0 1.5 0.03125 VGN 0 1.5 0.015625
let vgn = v(gn)
let vdn = v(dn)
let ovn = (vgn - 0.23 + abs(vgn - 0.23)) / 2
let sn = sqrt(0.03 * 0.03 + 0.65 * 0.65 * ovn * ovn)
let rn = nint(4096 / sn)
let fn = 1 - exp(0 - vdn * rn / 4096)
let idn = 0 - i(VDN)
let qn = (idn + abs(idn)) / 2
let jn = qn / (fn + 1e-30)
let mn = (jn + 1.1641532182693481e-12 + abs(jn - 1.1641532182693481e-12)) / 2
let lamn = nint(65536 / ln(2) * ln(mn / 1.1641532182693481e-12))
let k = 0
while k < 97
  let lamn[k*49] = dc1.l0n[k]
  let k = k + 1
end
echo BEGIN lam_n_0
print lamn
echo END lam_n_0
alter VDP = 1.5
dc VDP 1.5 0 -0.03125 VGP 1.5 0 -0.015625
let vgp = 1.5 - v(gp)
let vdp = 1.5 - v(dp)
let ovp = (vgp - 0.23 + abs(vgp - 0.23)) / 2
let sp = sqrt(0.03 * 0.03 + 0.65 * 0.65 * ovp * ovp)
let rp = nint(4096 / sp)
let fp = 1 - exp(0 - vdp * rp / 4096)
let idp = i(VDP)
let qp = (idp + abs(idp)) / 2
let jp = qp / (fp + 1e-30)
let mp = (jp + 1.1641532182693481e-12 + abs(jp - 1.1641532182693481e-12)) / 2
let lamp = nint(65536 / ln(2) * ln(mp / 1.1641532182693481e-12))
let k = 0
while k < 97
  let lamp[k*49] = dc2.l0p[k]
  let k = k + 1
end
echo BEGIN lam_p_0
print lamp
echo END lam_p_0
* ---- slice 1: Vsb = 0.25 V (the NMOS bulk at -0.25 V, the PMOS bulk at 1.75 V). Plots dc5, dc6: the Vds = 0 columns; dc7, dc8: the grids.
alter VBN = -0.25
alter VBP = 1.75
alter VDN = 0
dc VGN 0 1.5 0.015625
let gzn = @n.xmn.nsg13_lv_nmos[gds]
let kk = vector(97)
let vgk = kk * 0.015625
let ovk = (vgk - 0.23 + abs(vgk - 0.23)) / 2
let sk = sqrt(0.03 * 0.03 + 0.65 * 0.65 * ovk * ovk)
let rk = nint(4096 / sk)
let sek = 4096 / rk
let an = gzn * sek
let zn = (an + 1.1641532182693481e-12 + abs(an - 1.1641532182693481e-12)) / 2
let l0n = nint(65536 / ln(2) * ln(zn / 1.1641532182693481e-12))
alter VDP = 1.5
dc VGP 1.5 0 -0.015625
let gzp = @n.xmp.nsg13_lv_pmos[gds]
let kk = vector(97)
let vgk = kk * 0.015625
let ovk = (vgk - 0.23 + abs(vgk - 0.23)) / 2
let sk = sqrt(0.03 * 0.03 + 0.65 * 0.65 * ovk * ovk)
let rk = nint(4096 / sk)
let sek = 4096 / rk
let ap = gzp * sek
let zp = (ap + 1.1641532182693481e-12 + abs(ap - 1.1641532182693481e-12)) / 2
let l0p = nint(65536 / ln(2) * ln(zp / 1.1641532182693481e-12))
echo BEGIN r_1
print rk
echo END r_1
alter VDN = 0
dc VDN 0 1.5 0.03125 VGN 0 1.5 0.015625
let vgn = v(gn)
let vdn = v(dn)
let ovn = (vgn - 0.23 + abs(vgn - 0.23)) / 2
let sn = sqrt(0.03 * 0.03 + 0.65 * 0.65 * ovn * ovn)
let rn = nint(4096 / sn)
let fn = 1 - exp(0 - vdn * rn / 4096)
let idn = 0 - i(VDN)
let qn = (idn + abs(idn)) / 2
let jn = qn / (fn + 1e-30)
let mn = (jn + 1.1641532182693481e-12 + abs(jn - 1.1641532182693481e-12)) / 2
let lamn = nint(65536 / ln(2) * ln(mn / 1.1641532182693481e-12))
let k = 0
while k < 97
  let lamn[k*49] = dc5.l0n[k]
  let k = k + 1
end
echo BEGIN lam_n_1
print lamn
echo END lam_n_1
alter VDP = 1.5
dc VDP 1.5 0 -0.03125 VGP 1.5 0 -0.015625
let vgp = 1.5 - v(gp)
let vdp = 1.5 - v(dp)
let ovp = (vgp - 0.23 + abs(vgp - 0.23)) / 2
let sp = sqrt(0.03 * 0.03 + 0.65 * 0.65 * ovp * ovp)
let rp = nint(4096 / sp)
let fp = 1 - exp(0 - vdp * rp / 4096)
let idp = i(VDP)
let qp = (idp + abs(idp)) / 2
let jp = qp / (fp + 1e-30)
let mp = (jp + 1.1641532182693481e-12 + abs(jp - 1.1641532182693481e-12)) / 2
let lamp = nint(65536 / ln(2) * ln(mp / 1.1641532182693481e-12))
let k = 0
while k < 97
  let lamp[k*49] = dc6.l0p[k]
  let k = k + 1
end
echo BEGIN lam_p_1
print lamp
echo END lam_p_1
* ---- slice 2: Vsb = 0.5 V (the NMOS bulk at -0.5 V, the PMOS bulk at 2 V). Plots dc9, dc10: the Vds = 0 columns; dc11, dc12: the grids.
alter VBN = -0.5
alter VBP = 2
alter VDN = 0
dc VGN 0 1.5 0.015625
let gzn = @n.xmn.nsg13_lv_nmos[gds]
let kk = vector(97)
let vgk = kk * 0.015625
let ovk = (vgk - 0.23 + abs(vgk - 0.23)) / 2
let sk = sqrt(0.03 * 0.03 + 0.65 * 0.65 * ovk * ovk)
let rk = nint(4096 / sk)
let sek = 4096 / rk
let an = gzn * sek
let zn = (an + 1.1641532182693481e-12 + abs(an - 1.1641532182693481e-12)) / 2
let l0n = nint(65536 / ln(2) * ln(zn / 1.1641532182693481e-12))
alter VDP = 1.5
dc VGP 1.5 0 -0.015625
let gzp = @n.xmp.nsg13_lv_pmos[gds]
let kk = vector(97)
let vgk = kk * 0.015625
let ovk = (vgk - 0.23 + abs(vgk - 0.23)) / 2
let sk = sqrt(0.03 * 0.03 + 0.65 * 0.65 * ovk * ovk)
let rk = nint(4096 / sk)
let sek = 4096 / rk
let ap = gzp * sek
let zp = (ap + 1.1641532182693481e-12 + abs(ap - 1.1641532182693481e-12)) / 2
let l0p = nint(65536 / ln(2) * ln(zp / 1.1641532182693481e-12))
echo BEGIN r_2
print rk
echo END r_2
alter VDN = 0
dc VDN 0 1.5 0.03125 VGN 0 1.5 0.015625
let vgn = v(gn)
let vdn = v(dn)
let ovn = (vgn - 0.23 + abs(vgn - 0.23)) / 2
let sn = sqrt(0.03 * 0.03 + 0.65 * 0.65 * ovn * ovn)
let rn = nint(4096 / sn)
let fn = 1 - exp(0 - vdn * rn / 4096)
let idn = 0 - i(VDN)
let qn = (idn + abs(idn)) / 2
let jn = qn / (fn + 1e-30)
let mn = (jn + 1.1641532182693481e-12 + abs(jn - 1.1641532182693481e-12)) / 2
let lamn = nint(65536 / ln(2) * ln(mn / 1.1641532182693481e-12))
let k = 0
while k < 97
  let lamn[k*49] = dc9.l0n[k]
  let k = k + 1
end
echo BEGIN lam_n_2
print lamn
echo END lam_n_2
alter VDP = 1.5
dc VDP 1.5 0 -0.03125 VGP 1.5 0 -0.015625
let vgp = 1.5 - v(gp)
let vdp = 1.5 - v(dp)
let ovp = (vgp - 0.23 + abs(vgp - 0.23)) / 2
let sp = sqrt(0.03 * 0.03 + 0.65 * 0.65 * ovp * ovp)
let rp = nint(4096 / sp)
let fp = 1 - exp(0 - vdp * rp / 4096)
let idp = i(VDP)
let qp = (idp + abs(idp)) / 2
let jp = qp / (fp + 1e-30)
let mp = (jp + 1.1641532182693481e-12 + abs(jp - 1.1641532182693481e-12)) / 2
let lamp = nint(65536 / ln(2) * ln(mp / 1.1641532182693481e-12))
let k = 0
while k < 97
  let lamp[k*49] = dc10.l0p[k]
  let k = k + 1
end
echo BEGIN lam_p_2
print lamp
echo END lam_p_2
* ---- slice 3: Vsb = 0.75 V (the NMOS bulk at -0.75 V, the PMOS bulk at 2.25 V). Plots dc13, dc14: the Vds = 0 columns; dc15, dc16: the grids.
alter VBN = -0.75
alter VBP = 2.25
alter VDN = 0
dc VGN 0 1.5 0.015625
let gzn = @n.xmn.nsg13_lv_nmos[gds]
let kk = vector(97)
let vgk = kk * 0.015625
let ovk = (vgk - 0.23 + abs(vgk - 0.23)) / 2
let sk = sqrt(0.03 * 0.03 + 0.65 * 0.65 * ovk * ovk)
let rk = nint(4096 / sk)
let sek = 4096 / rk
let an = gzn * sek
let zn = (an + 1.1641532182693481e-12 + abs(an - 1.1641532182693481e-12)) / 2
let l0n = nint(65536 / ln(2) * ln(zn / 1.1641532182693481e-12))
alter VDP = 1.5
dc VGP 1.5 0 -0.015625
let gzp = @n.xmp.nsg13_lv_pmos[gds]
let kk = vector(97)
let vgk = kk * 0.015625
let ovk = (vgk - 0.23 + abs(vgk - 0.23)) / 2
let sk = sqrt(0.03 * 0.03 + 0.65 * 0.65 * ovk * ovk)
let rk = nint(4096 / sk)
let sek = 4096 / rk
let ap = gzp * sek
let zp = (ap + 1.1641532182693481e-12 + abs(ap - 1.1641532182693481e-12)) / 2
let l0p = nint(65536 / ln(2) * ln(zp / 1.1641532182693481e-12))
echo BEGIN r_3
print rk
echo END r_3
alter VDN = 0
dc VDN 0 1.5 0.03125 VGN 0 1.5 0.015625
let vgn = v(gn)
let vdn = v(dn)
let ovn = (vgn - 0.23 + abs(vgn - 0.23)) / 2
let sn = sqrt(0.03 * 0.03 + 0.65 * 0.65 * ovn * ovn)
let rn = nint(4096 / sn)
let fn = 1 - exp(0 - vdn * rn / 4096)
let idn = 0 - i(VDN)
let qn = (idn + abs(idn)) / 2
let jn = qn / (fn + 1e-30)
let mn = (jn + 1.1641532182693481e-12 + abs(jn - 1.1641532182693481e-12)) / 2
let lamn = nint(65536 / ln(2) * ln(mn / 1.1641532182693481e-12))
let k = 0
while k < 97
  let lamn[k*49] = dc13.l0n[k]
  let k = k + 1
end
echo BEGIN lam_n_3
print lamn
echo END lam_n_3
alter VDP = 1.5
dc VDP 1.5 0 -0.03125 VGP 1.5 0 -0.015625
let vgp = 1.5 - v(gp)
let vdp = 1.5 - v(dp)
let ovp = (vgp - 0.23 + abs(vgp - 0.23)) / 2
let sp = sqrt(0.03 * 0.03 + 0.65 * 0.65 * ovp * ovp)
let rp = nint(4096 / sp)
let fp = 1 - exp(0 - vdp * rp / 4096)
let idp = i(VDP)
let qp = (idp + abs(idp)) / 2
let jp = qp / (fp + 1e-30)
let mp = (jp + 1.1641532182693481e-12 + abs(jp - 1.1641532182693481e-12)) / 2
let lamp = nint(65536 / ln(2) * ln(mp / 1.1641532182693481e-12))
let k = 0
while k < 97
  let lamp[k*49] = dc14.l0p[k]
  let k = k + 1
end
echo BEGIN lam_p_3
print lamp
echo END lam_p_3
* ---- slice 4: Vsb = 1 V (the NMOS bulk at -1 V, the PMOS bulk at 2.5 V). Plots dc17, dc18: the Vds = 0 columns; dc19, dc20: the grids.
alter VBN = -1
alter VBP = 2.5
alter VDN = 0
dc VGN 0 1.5 0.015625
let gzn = @n.xmn.nsg13_lv_nmos[gds]
let kk = vector(97)
let vgk = kk * 0.015625
let ovk = (vgk - 0.23 + abs(vgk - 0.23)) / 2
let sk = sqrt(0.03 * 0.03 + 0.65 * 0.65 * ovk * ovk)
let rk = nint(4096 / sk)
let sek = 4096 / rk
let an = gzn * sek
let zn = (an + 1.1641532182693481e-12 + abs(an - 1.1641532182693481e-12)) / 2
let l0n = nint(65536 / ln(2) * ln(zn / 1.1641532182693481e-12))
alter VDP = 1.5
dc VGP 1.5 0 -0.015625
let gzp = @n.xmp.nsg13_lv_pmos[gds]
let kk = vector(97)
let vgk = kk * 0.015625
let ovk = (vgk - 0.23 + abs(vgk - 0.23)) / 2
let sk = sqrt(0.03 * 0.03 + 0.65 * 0.65 * ovk * ovk)
let rk = nint(4096 / sk)
let sek = 4096 / rk
let ap = gzp * sek
let zp = (ap + 1.1641532182693481e-12 + abs(ap - 1.1641532182693481e-12)) / 2
let l0p = nint(65536 / ln(2) * ln(zp / 1.1641532182693481e-12))
echo BEGIN r_4
print rk
echo END r_4
alter VDN = 0
dc VDN 0 1.5 0.03125 VGN 0 1.5 0.015625
let vgn = v(gn)
let vdn = v(dn)
let ovn = (vgn - 0.23 + abs(vgn - 0.23)) / 2
let sn = sqrt(0.03 * 0.03 + 0.65 * 0.65 * ovn * ovn)
let rn = nint(4096 / sn)
let fn = 1 - exp(0 - vdn * rn / 4096)
let idn = 0 - i(VDN)
let qn = (idn + abs(idn)) / 2
let jn = qn / (fn + 1e-30)
let mn = (jn + 1.1641532182693481e-12 + abs(jn - 1.1641532182693481e-12)) / 2
let lamn = nint(65536 / ln(2) * ln(mn / 1.1641532182693481e-12))
let k = 0
while k < 97
  let lamn[k*49] = dc17.l0n[k]
  let k = k + 1
end
echo BEGIN lam_n_4
print lamn
echo END lam_n_4
alter VDP = 1.5
dc VDP 1.5 0 -0.03125 VGP 1.5 0 -0.015625
let vgp = 1.5 - v(gp)
let vdp = 1.5 - v(dp)
let ovp = (vgp - 0.23 + abs(vgp - 0.23)) / 2
let sp = sqrt(0.03 * 0.03 + 0.65 * 0.65 * ovp * ovp)
let rp = nint(4096 / sp)
let fp = 1 - exp(0 - vdp * rp / 4096)
let idp = i(VDP)
let qp = (idp + abs(idp)) / 2
let jp = qp / (fp + 1e-30)
let mp = (jp + 1.1641532182693481e-12 + abs(jp - 1.1641532182693481e-12)) / 2
let lamp = nint(65536 / ln(2) * ln(mp / 1.1641532182693481e-12))
let k = 0
while k < 97
  let lamp[k*49] = dc18.l0p[k]
  let k = k + 1
end
echo BEGIN lam_p_4
print lamp
echo END lam_p_4
* ---- slice 5: Vsb = 1.25 V (the NMOS bulk at -1.25 V, the PMOS bulk at 2.75 V). Plots dc21, dc22: the Vds = 0 columns; dc23, dc24: the grids.
alter VBN = -1.25
alter VBP = 2.75
alter VDN = 0
dc VGN 0 1.5 0.015625
let gzn = @n.xmn.nsg13_lv_nmos[gds]
let kk = vector(97)
let vgk = kk * 0.015625
let ovk = (vgk - 0.23 + abs(vgk - 0.23)) / 2
let sk = sqrt(0.03 * 0.03 + 0.65 * 0.65 * ovk * ovk)
let rk = nint(4096 / sk)
let sek = 4096 / rk
let an = gzn * sek
let zn = (an + 1.1641532182693481e-12 + abs(an - 1.1641532182693481e-12)) / 2
let l0n = nint(65536 / ln(2) * ln(zn / 1.1641532182693481e-12))
alter VDP = 1.5
dc VGP 1.5 0 -0.015625
let gzp = @n.xmp.nsg13_lv_pmos[gds]
let kk = vector(97)
let vgk = kk * 0.015625
let ovk = (vgk - 0.23 + abs(vgk - 0.23)) / 2
let sk = sqrt(0.03 * 0.03 + 0.65 * 0.65 * ovk * ovk)
let rk = nint(4096 / sk)
let sek = 4096 / rk
let ap = gzp * sek
let zp = (ap + 1.1641532182693481e-12 + abs(ap - 1.1641532182693481e-12)) / 2
let l0p = nint(65536 / ln(2) * ln(zp / 1.1641532182693481e-12))
echo BEGIN r_5
print rk
echo END r_5
alter VDN = 0
dc VDN 0 1.5 0.03125 VGN 0 1.5 0.015625
let vgn = v(gn)
let vdn = v(dn)
let ovn = (vgn - 0.23 + abs(vgn - 0.23)) / 2
let sn = sqrt(0.03 * 0.03 + 0.65 * 0.65 * ovn * ovn)
let rn = nint(4096 / sn)
let fn = 1 - exp(0 - vdn * rn / 4096)
let idn = 0 - i(VDN)
let qn = (idn + abs(idn)) / 2
let jn = qn / (fn + 1e-30)
let mn = (jn + 1.1641532182693481e-12 + abs(jn - 1.1641532182693481e-12)) / 2
let lamn = nint(65536 / ln(2) * ln(mn / 1.1641532182693481e-12))
let k = 0
while k < 97
  let lamn[k*49] = dc21.l0n[k]
  let k = k + 1
end
echo BEGIN lam_n_5
print lamn
echo END lam_n_5
alter VDP = 1.5
dc VDP 1.5 0 -0.03125 VGP 1.5 0 -0.015625
let vgp = 1.5 - v(gp)
let vdp = 1.5 - v(dp)
let ovp = (vgp - 0.23 + abs(vgp - 0.23)) / 2
let sp = sqrt(0.03 * 0.03 + 0.65 * 0.65 * ovp * ovp)
let rp = nint(4096 / sp)
let fp = 1 - exp(0 - vdp * rp / 4096)
let idp = i(VDP)
let qp = (idp + abs(idp)) / 2
let jp = qp / (fp + 1e-30)
let mp = (jp + 1.1641532182693481e-12 + abs(jp - 1.1641532182693481e-12)) / 2
let lamp = nint(65536 / ln(2) * ln(mp / 1.1641532182693481e-12))
let k = 0
while k < 97
  let lamp[k*49] = dc22.l0p[k]
  let k = k + 1
end
echo BEGIN lam_p_5
print lamp
echo END lam_p_5
* ---- slice 6: Vsb = 1.5 V (the NMOS bulk at -1.5 V, the PMOS bulk at 3 V). Plots dc25, dc26: the Vds = 0 columns; dc27, dc28: the grids.
alter VBN = -1.5
alter VBP = 3
alter VDN = 0
dc VGN 0 1.5 0.015625
let gzn = @n.xmn.nsg13_lv_nmos[gds]
let kk = vector(97)
let vgk = kk * 0.015625
let ovk = (vgk - 0.23 + abs(vgk - 0.23)) / 2
let sk = sqrt(0.03 * 0.03 + 0.65 * 0.65 * ovk * ovk)
let rk = nint(4096 / sk)
let sek = 4096 / rk
let an = gzn * sek
let zn = (an + 1.1641532182693481e-12 + abs(an - 1.1641532182693481e-12)) / 2
let l0n = nint(65536 / ln(2) * ln(zn / 1.1641532182693481e-12))
alter VDP = 1.5
dc VGP 1.5 0 -0.015625
let gzp = @n.xmp.nsg13_lv_pmos[gds]
let kk = vector(97)
let vgk = kk * 0.015625
let ovk = (vgk - 0.23 + abs(vgk - 0.23)) / 2
let sk = sqrt(0.03 * 0.03 + 0.65 * 0.65 * ovk * ovk)
let rk = nint(4096 / sk)
let sek = 4096 / rk
let ap = gzp * sek
let zp = (ap + 1.1641532182693481e-12 + abs(ap - 1.1641532182693481e-12)) / 2
let l0p = nint(65536 / ln(2) * ln(zp / 1.1641532182693481e-12))
echo BEGIN r_6
print rk
echo END r_6
alter VDN = 0
dc VDN 0 1.5 0.03125 VGN 0 1.5 0.015625
let vgn = v(gn)
let vdn = v(dn)
let ovn = (vgn - 0.23 + abs(vgn - 0.23)) / 2
let sn = sqrt(0.03 * 0.03 + 0.65 * 0.65 * ovn * ovn)
let rn = nint(4096 / sn)
let fn = 1 - exp(0 - vdn * rn / 4096)
let idn = 0 - i(VDN)
let qn = (idn + abs(idn)) / 2
let jn = qn / (fn + 1e-30)
let mn = (jn + 1.1641532182693481e-12 + abs(jn - 1.1641532182693481e-12)) / 2
let lamn = nint(65536 / ln(2) * ln(mn / 1.1641532182693481e-12))
let k = 0
while k < 97
  let lamn[k*49] = dc25.l0n[k]
  let k = k + 1
end
echo BEGIN lam_n_6
print lamn
echo END lam_n_6
alter VDP = 1.5
dc VDP 1.5 0 -0.03125 VGP 1.5 0 -0.015625
let vgp = 1.5 - v(gp)
let vdp = 1.5 - v(dp)
let ovp = (vgp - 0.23 + abs(vgp - 0.23)) / 2
let sp = sqrt(0.03 * 0.03 + 0.65 * 0.65 * ovp * ovp)
let rp = nint(4096 / sp)
let fp = 1 - exp(0 - vdp * rp / 4096)
let idp = i(VDP)
let qp = (idp + abs(idp)) / 2
let jp = qp / (fp + 1e-30)
let mp = (jp + 1.1641532182693481e-12 + abs(jp - 1.1641532182693481e-12)) / 2
let lamp = nint(65536 / ln(2) * ln(mp / 1.1641532182693481e-12))
let k = 0
while k < 97
  let lamp[k*49] = dc26.l0p[k]
  let k = k + 1
end
echo BEGIN lam_p_6
print lamp
echo END lam_p_6
* the held-out currents: the bulks back where the sweeps found them do not matter, the held-out devices have their own bulk sources
echo BEGIN cen_n
dc VK 1 1000 1
let u = nint(i(VRDN) * 1e12)
print u
echo END cen_n
echo BEGIN cen_p
let u = nint(i(VRDP) * 1e12)
print u
echo END cen_p
.endc
.end
