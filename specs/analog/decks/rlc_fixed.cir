M1 series RLC, backward Euler on a fixed 5 ns grid
* specs/analog/decks/rlc_fixed.cir -- test data for specs/analog/bench.t27 (#10505). A plain netlist, no .control block.
* Circuit: R1 = 100 Ohm from IN to node 1, L1 = 10 uH from node 1 to node 2 (the capacitor voltage), C1 = 1 nF from
* node 2 to ground; capacitor voltage and inductor current start at 0 (specs/analog/linear.t27, circuit 2).
* Run: 200 steps of 5 ns, IN = 1 V for the first 100 steps and 0 V for the next 100.
* The grid is made exact as in rc_fixed.cir: a B source declares no breakpoint, the circuit rests at 0 while the source
* is 0, the source turns on at 42.5 ns (half a step from the nearest grid point) and turns off at 542.5 ns, and from the
* first internal point after 42.5 ns every step is 5 ns. Step k (k = 0..199) ends at the k-th internal point after 42.5 ns.
* tstop = 42.5 ns + 201 steps. gear with maxord 1 is backward Euler; trtol = 1e7 stops the truncation test.
* Run: ngspice -b -r rlc_fixed.raw rlc_fixed.cir   (the raw file holds float64 values)
B1 in 0 V = u(time-42.5n) - u(time-542.5n)
R1 in 1 100
L1 1 2 10u IC=0
C1 2 0 1n IC=0
.options method=gear maxord=1 trtol=1e7
.tran 5n 1047.5n 0 5n uic
.end
