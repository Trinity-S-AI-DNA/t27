IHP SG13G2 inverter into 20 fF, converged reference (trapezoidal rule, steps of at most 0.05 ps), corner mos_tt, 27 C
* specs/analog/decks/psp103_inv20_fine.cir -- reference data for specs/analog/mos_psp103_inv20.t27 and its use in specs/analog/accept_sar.t27 (analog M5e, #11350, epic #10486).
* The inverter of the golden SAR ADC netlist: a pmos 3.0 um / 0.45 um with its bulk on the supply, an nmos 1.0 um / 0.45 um with its bulk on ground, ng 1, m 1 (facts of the circuit,
* the W, L and m of psp103_inv_be_500f.cir; none of the golden deck's text), loaded by 20 fF on the output and nothing else: the load of the report's row "delays fall / rise into 20 fF".
* Model: IHP SG13G2 PSP103 of IHP-Open-PDK 21133f21, section mos_tt, through ngspice-47 and OSDI. Paths are NOT in this file: ngspice reads IHP_PDK and IHP_OSDI from the environment.
* Run: IHP_PDK=<checkout> IHP_OSDI=<osdi dir> ngspice -b psp103_inv20_fine.cir    (ngspice-47)
* The input is an IDEAL step (a B source of u(time - t0), no slew, so that the table model's gate edge, one jump of the node's charge, is the same edge): the gate is at the supply until 1 ns,
* falls to 0 V at 1 ns (the output rises) and returns to the supply at 2 ns (the output falls). Each level is held for 1 ns, 20 delays, so the output has settled to well under a microvolt. The time
* step is held to 0.05 ps (1/80 of the 4 ps grid of the table model's coarsest run), the settings of psp103_inv_fine_500f.cir otherwise.
* What it prints (ngspice .meas, 10 digits): tplh and tphl, the times at which the output crosses 0.75 V rising after the edge at 1 ns and falling after the edge at 2 ns (the input crosses 0.75 V AT the
* edge, so the delays are these minus 1 ns and minus 2 ns); the rest levels at 0.9, 1.9 and 2.9 ns; the lowest the output goes after the first edge (the kick below ground) and the highest after the
* second (the kick above the supply) with the times they happen; and the output at fixed times after each edge, between "SAMPLES <edge>" lines, as the table model's waveform is compared.
* The two blocks "COARSE 0.2p" and "COARSE 0.01p" run the same circuit again with the step held to 0.2 ps and to 0.01 ps and print the two crossings, so that the reference's own sensitivity to
* its time step is a number of this deck (the delays of the three runs are tplh, tphl; tplh2, tphl2; tplh3, tphl3).
.lib $IHP_PDK/ihp-sg13g2/libs.tech/ngspice/models/cornerMOSlv.lib mos_tt
VDD vdd 0 1.5
Bin in 0 V = 1.5*(1-u(time-1n)+u(time-2n))
XIP out in vdd vdd sg13_lv_pmos w=3.0u l=0.45u ng=1 m=1
XIN out in 0 0 sg13_lv_nmos w=1.0u l=0.45u ng=1 m=1
CL out 0 20f
.temp 27
.options reltol=1e-6 vntol=1e-9 abstol=1e-12 itl4=200
.control
set num_threads=2
pre_osdi $IHP_OSDI/psp103.osdi
pre_osdi $IHP_OSDI/psp103_nqs.osdi
set numdgt=10
set noprintscale
tran 0.1p 3n 0 0.05p
echo EDGES
meas tran tplh when v(out)=0.75 rise=1
meas tran tphl when v(out)=0.75 fall=1
print tplh tphl
echo RESTS
meas tran rest0 find v(out) at=0.9n
meas tran rest1 find v(out) at=1.9n
meas tran rest2 find v(out) at=2.9n
echo KICKS
meas tran vlow min v(out) from=1n to=1.2n
meas tran tlow min_at v(out) from=1n to=1.2n
meas tran vhigh max v(out) from=2n to=2.2n
meas tran thigh max_at v(out) from=2n to=2.2n
echo SAMPLES 1
foreach dtn 0.5p 1p 2p 3p 4p 5p 7.5p 10p 15p 20p 25p 30p 40p 50p 60p 80p 100p 150p 200p 400p
  let tt = 1n + $dtn
  echo T $dtn
  meas tran vs find v(out) at=$&tt
end
echo SAMPLES 2
foreach dtn 0.5p 1p 2p 3p 4p 5p 7.5p 10p 15p 20p 25p 30p 40p 50p 60p 80p 100p 150p 200p 400p
  let tt = 2n + $dtn
  echo T $dtn
  meas tran vs find v(out) at=$&tt
end
echo COARSE 0.2p
tran 0.1p 3n 0 0.2p
meas tran tplh2 when v(out)=0.75 rise=1
meas tran tphl2 when v(out)=0.75 fall=1
print tplh2 tphl2
echo COARSE 0.01p
tran 0.1p 3n 0 0.01p
meas tran tplh3 when v(out)=0.75 rise=1
meas tran tphl3 when v(out)=0.75 fall=1
print tplh3 tphl3
.endc
.end
