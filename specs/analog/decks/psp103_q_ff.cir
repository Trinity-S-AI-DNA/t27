IHP SG13G2 PSP103 drain and gate charge tables, corner mos_ff
* specs/analog/decks/psp103_q_ff.cir -- charge table data for specs/analog/mos_psp103_data.t27 (M3c, #10777, epic #10486). A netlist plus a
* .control block that prints the numbers. The same deck exists for each of the five corners (psp103_q_tt, _ss, _ff, _fs, _sf .cir); they differ in the title and the .lib section.
* The IHP corner file is read at run time and never copied here.
* Model: IHP-Open-PDK commit 21133f219b1a6da10d803e345761e77415ceff40, ihp-sg13g2/libs.tech/ngspice/models/cornerMOSlv.lib (PSP 103.6,
* revision 200310), section mos_ff; the model code is libs.tech/verilog-a/psp103/psp103.va of the same commit, compiled with
* OpenVAF-Reloaded v24.0.2mob to psp103.osdi (and psp103_nqs.osdi). Temperature 27 C (TNOM 27 C). Devices: sg13_lv_nmos w=1.0u l=0.45u
* ng=1 m=1 and sg13_lv_pmos w=3.0u l=0.45u ng=1 m=1, exactly the devices of psp103_tab_ff.cir (the same netlist lines), on the same
* 25 x 25 grid of 62.5 mV over 0 .. 1.5 V.
* Solver options: reltol 1e-6, vntol 1e-9, abstol 1e-14, as psp103_tab_ff.cir.
* Paths are NOT in this file. ngspice reads two environment variables: IHP_PDK, the IHP-Open-PDK checkout, and IHP_OSDI, the directory that
* holds the compiled psp103.osdi and psp103_nqs.osdi.
* Run: IHP_PDK=<checkout> IHP_OSDI=<osdi dir> ngspice -b psp103_q_ff.cir > psp103_q_ff.out    (ngspice-47)
* WHICH VARIABLES. PSP103 reports no terminal charge as an output variable: `show` on the OSDI instance lists currents (ids, ige, ...), conductances
* (gm, gmb, gds) and capacitances (cdd, cdg, cgg, cgd, ..., plus the overlap cgsol, cgdol and the junction cjs, cjd, each reported apart), and
* no q*. The charge is therefore taken from the terminal CURRENTS of a backward Euler step, which is what ngspice itself integrates: for a step
* of dt from state A to state B the current into a terminal is i(B) = Idc(B) + (Q(B) - Q(A)) / dt, with Q the terminal's whole charge
* (channel, overlap, fringe and junction parts together), so Q(B) - Q(A) = (i(B) - Idc(B)) dt. The drive is a staircase: node k of the grid
* (ix = k / 25 along Vgs, iy = k mod 25 along Vds) is visited from the origin A = (0, 0) and the bias goes back to A on the next step. The
* return step is the one measured: its end state is the origin, where the device is off and Idc(A) is the current of the first step, so the
* subtraction is of a current of picoamps, not of the 400 uA of a node in strong inversion. Then
*     Q(B) - Q(A) = (i_A - i_return) dt        with i_A the terminal current at the origin before the first jump and i_return at the end of the return step.
* The step is dt = 10 ns, long against the gate resistance of the model (about 29 ohm times a few fF is 0.1 ps), so the gate network has settled
* and the charge is the quasi-static one. (At dt = 100 ps the settling is 1 part in 1000 and the outgoing step, measured against the DC current of the
* node, shows it as a current deficit of tau gm dV, which is why the outgoing step is not used.)
* What it prints. Between "BEGIN name" and "END name" every row "<index> TAB <value>" is one number, in sweep order (index = ix * 25 + iy). The
* values are pasted into the spec in that order, none changed.
*   grid_n, grid_p  Id of the nmos at Vgs = ix * 62.5 mV, Vds = iy * 62.5 mV and of the pmos at Vsg, Vsd, exactly as psp103_tab_ff.cir prints them
*           (units of 2^-24 V, dt/C = 200 V/A): the current tables and the charge tables come from one run of one netlist. Negative values held at 0.
*   op_n    cdd, cdg, cgg, cgsol, cgdol, cjd of the nmos at Vgs = 0.9 V, Vds = 0.75 V in aF, as ngspice reports them: the channel capacitances
*           (cdd = dQd/dVd, cdg = dQd/dVg, cgg = dQg/dVg of the intrinsic charges), the gate-source and gate-drain overlaps and the drain junction, each apart.
*   qd_n    the DRAIN charge of the nmos. Unit: Q / 500 fF in units of 2^-24 V, that is the voltage a 500 fF node moves when it takes the charge, so
*           one unit is 500 fF * 59.6 nV = 2.98e-20 C (0.19 electron). Entry = nint(2e12 * 2^24 * (Q(B) - Q(A))) + 2^21: the charge relative to the
*           origin Vgs = Vds = 0, plus 2^21 so that no entry is negative. The offset is arbitrary; only differences are physical.
*   qg_n    the GATE charge of the nmos, the same unit and offset.
*   qd_p    the DRAIN charge of the pmos at Vsg = ix * 62.5 mV, Vsd = iy * 62.5 mV (source and bulk on the 1.5 V rail), NEGATED: entry =
*           2^21 - nint(2e12 * 2^24 * (Q(B) - Q(A))), so that it grows with Vsd as the nmos' does (capacitances are positive: the drain charge grows with
*           the drain voltage, which falls as Vsd grows).
*   qg_p    the GATE charge of the pmos, negated the same way (grows with Vsg).
*   tchk    the largest distance of an ngspice time point used from the grid k * 10 ns, in s: 0 when every row used is a step end.
* nmos tran device: drain and gate on B sources through zero-volt current meters; the source and bulk at 0 V
.lib $IHP_PDK/ihp-sg13g2/libs.tech/ngspice/models/cornerMOSlv.lib mos_ff
.func kst() {nint(time/1e-8)}
.func nd() {max(floor(kst()/2)-1,0)}
.func act() {(time<1e-3)*(kst()>=2)*((kst()-2*floor(kst()/2))==0)}
.func ixf() {floor(nd()/25)}
.func iyf() {nd()-25*floor(nd()/25)}
* (act() is 0 in a DC sweep: ngspice puts the swept value into `time`, which is at least 62.5 mV there and below 13 us in the transient.)
BDN tdn 0 V = act()*0.0625*iyf()
BGN tgn 0 V = act()*0.0625*ixf()
VMDN tdn tdnn 0
VMGN tgn tgnn 0
XTN tdnn tgnn 0 0 sg13_lv_nmos w=1.0u l=0.45u ng=1 m=1
* pmos tran device: source and bulk at the 1.5 V rail; the origin is Vsg = Vsd = 0
VTSP tsp 0 1.5
BDP tdp 0 V = 1.5-act()*0.0625*iyf()
BGP tgp 0 V = 1.5-act()*0.0625*ixf()
VMDP tdp tdpp 0
VMGP tgp tgpp 0
XTP tdpp tgpp tsp tsp sg13_lv_pmos w=3.0u l=0.45u ng=1 m=1
* nmos table device: drain VDN, gate VGN, source and bulk at 0 V (as psp103_tab_ff.cir)
VDN dn 0 0
VGN gn 0 0
XMN dn gn 0 0 sg13_lv_nmos w=1.0u l=0.45u ng=1 m=1
* pmos table device: source and bulk at the 1.5 V rail, drain VDP and gate VGP, both swept downward from 1.5 V
VSP sp 0 1.5
VDP dp 0 1.5
VGP gp 0 1.5
XMP dp gp sp sp sg13_lv_pmos w=3.0u l=0.45u ng=1 m=1
.temp 27
.options reltol=1e-6 vntol=1e-9 abstol=1e-14
.options method=gear maxord=1 trtol=1e7 itl4=200
.control
pre_osdi $IHP_OSDI/psp103.osdi
pre_osdi $IHP_OSDI/psp103_nqs.osdi
set numdgt=10
set noprintscale
echo BEGIN grid_n
dc VDN 0 1.5 0.0625 VGN 0 1.5 0.0625
let u = nint(-i(VDN) * 200 * 16777216)
let u = (u + abs(u)) / 2
print u
echo END grid_n
echo BEGIN grid_p
dc VDP 1.5 0 -0.0625 VGP 1.5 0 -0.0625
let u = nint(i(VDP) * 200 * 16777216)
let u = (u + abs(u)) / 2
print u
echo END grid_p
* the capacitances ngspice itself reports at one operating point of the nmos, Vgs = 0.9 V, Vds = 0.75 V, in aF (nint(C * 1e18)): the cross-check of
* the charge tables, which are made from currents and never see these
alter VDN = 0.75
alter VGN = 0.9
op
let c_dd = nint(@n.xmn.nsg13_lv_nmos[cdd] * 1e18)
let c_dg = nint(@n.xmn.nsg13_lv_nmos[cdg] * 1e18)
let c_gg = nint(@n.xmn.nsg13_lv_nmos[cgg] * 1e18)
let c_gsol = nint(@n.xmn.nsg13_lv_nmos[cgsol] * 1e18)
let c_gdol = nint(@n.xmn.nsg13_lv_nmos[cgdol] * 1e18)
let c_jd = nint(@n.xmn.nsg13_lv_nmos[cjd] * 1e18)
echo BEGIN op_n
print c_dd c_dg c_gg c_gsol c_gdol c_jd
echo END op_n
tran 7.8125n 12.54u 0 10n
let dn0 = i(vmdn)[8]
let gn0 = i(vmgn)[8]
let dp0 = i(vmdp)[8]
let gp0 = i(vmgp)[8]
let qdn = unitvec(625)
let qgn = unitvec(625)
let qdp = unitvec(625)
let qgp = unitvec(625)
let tchk = abs(time[8] - 1e-8)
let k = 0
while k < 625
  let r = 2*k + 10
  let tchk = max(tchk, abs(time[r] - (2*k+3)*1e-8))
  let qdn[k] = nint((dn0 - i(vmdn)[r]) * 1e-8 * 2e12 * 16777216) + 2097152
  let qgn[k] = nint((gn0 - i(vmgn)[r]) * 1e-8 * 2e12 * 16777216) + 2097152
  let qdp[k] = 2097152 - nint((dp0 - i(vmdp)[r]) * 1e-8 * 2e12 * 16777216)
  let qgp[k] = 2097152 - nint((gp0 - i(vmgp)[r]) * 1e-8 * 2e12 * 16777216)
  let k = k + 1
end
echo BEGIN qd_n
print qdn
echo END qd_n
echo BEGIN qg_n
print qgn
echo END qg_n
echo BEGIN qd_p
print qdp
echo END qd_p
echo BEGIN qg_p
print qgp
echo END qg_p
echo BEGIN tchk
print tchk
echo END tchk
.endc
.end
