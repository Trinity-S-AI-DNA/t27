IHP SG13G2 MOS gate node loaded by a MOS drain, 25 fF, backward Euler on a fixed 5 ps grid, corner mos_tt
* specs/analog/decks/psp103_gate_node.cir -- reference data for specs/analog/mos_psp103.t27 (M3c-3, #10882, epic #10486). A netlist plus
* a .control block that prints the waveform of one node.
* The circuit has an internal GATE NODE g: the gate of one sg13_lv_nmos (w=1.0u l=0.45u, source and bulk at 0 V, drain at the 1.5 V rail, so its
* Vds is 1.5 V whatever g does: its gate charge is the NMOS gate-charge table read along Vds = 1.5 V), loaded by the DRAIN of one sg13_lv_pmos
* (w=3.0u l=0.45u, source and bulk at the 1.5 V rail, gate `in`), by a 25 fF capacitor to ground (the node's own capacitance) and by a 10 kohm
* resistor to a 0.75 V bias, which holds the node at 0.75 V at rest. `in` is at 1.5 V (the PMOS off), then 0 V for 8 steps, then 1.5 V again: the
* falling edge of `in` takes charge off the node through the PMOS' gate-drain coupling (a jump of charge: the node moves by 0.15 V in the first step
* before the PMOS current can act) and the PMOS then charges the node; the rising edge takes the coupling back, and the node relaxes to its bias through
* the resistor. The node stays between 0.59 V and 1.08 V, inside the range of the tables, which the rails of an inverter's output would not: an
* inverter's output kicked by its own gate edge goes through 0 V and 1.5 V (32 mV and 38 mV beyond them at 100 fF), where the tables end. g holds, besides
* the capacitor and the resistor, the drain charge of the PMOS and the gate charge of the loading NMOS: the first circuit in which the gate charge
* tables are read. The tables' unit is dt / C = 200 V/A, as in the 500 fF run: dt = 5 ps on C = 25 fF, so the same current tables apply and the
* charge tables (Q / 500 fF) are scaled by 500 fF / 25 fF = 20.
* Paths are NOT in this file: ngspice reads IHP_PDK and IHP_OSDI from the environment (see psp103_tab_tt.cir).
* Run: IHP_PDK=<checkout> IHP_OSDI=<osdi dir> ngspice -b psp103_gate_node.cir    (ngspice-47)
* Grid: as psp103_inv_be_500f.cir with dt = 5 ps: tstep = 0.78125 dt makes the opening ramp end exactly at dt, so every internal point from then
* on is a multiple of dt. The input is a B source of nint(time / dt): 1.5 V up to index 1, 0 V from index 2 (10 ps) to index 9, 1.5 V from index 10.
* Step k of the spec ends at (k + 2) dt; step 0 starts at t = dt = 5 ps and step 8 at 9 dt = 45 ps.
* What it prints: between "BEGIN tran_be" and "END tran_be", 401 rows "<index> TAB <time> TAB <y>", y the node g in units of 2^-24 V at t = 5 ps,
* 10 ps, ... 2.005 ns (row 0 is the circuit at rest before step 0, row k + 1 the node after step k).
.lib $IHP_PDK/ihp-sg13g2/libs.tech/ngspice/models/cornerMOSlv.lib mos_tt
VB vb 0 0.75
VDD vdd 0 1.5
Bin in 0 V = 1.5*(1-min(max(nint(time/5e-12)-1,0),1)+min(max(nint(time/5e-12)-9,0),1))
XP g in vdd vdd sg13_lv_pmos w=3.0u l=0.45u ng=1 m=1
XM1 vdd g 0 0 sg13_lv_nmos w=1.0u l=0.45u ng=1 m=1
CG g 0 25f
RB g vb 10k
.temp 27
.options method=gear maxord=1 trtol=1e7 reltol=1e-6 vntol=1e-9 abstol=1e-12 itl4=200
.tran 3.90625p 2.02n 0 5p
.control
pre_osdi $IHP_OSDI/psp103.osdi
pre_osdi $IHP_OSDI/psp103_nqs.osdi
run
set numdgt=10
set noprintscale
let y = nint(v(g) * 16777216)
let ts = time[8,408]
let ys = y[8,408]
echo BEGIN tran_be
print ts ys
echo END tran_be
.endc
.end
