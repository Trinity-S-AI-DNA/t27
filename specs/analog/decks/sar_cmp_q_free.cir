SAR ADC dynamic comparator on PSP103 at 27 C, net1 left to float: the DC operating point of the circuit with the clock low
* specs/analog/decks/sar_cmp_q_free.cir -- reference data for specs/analog/sar_comparator_q.t27 (analog M4b-q, #11312, epic #10486). The netlist of sar_cmp_q_ref.cir (read its header) with
* the .ic replaced by a .nodeset (a guess for the operating point, which does not force anything): ngspice solves the DC operating point of the circuit with the clock low, where
* net1, which no switch resets, settles where the leakage of the input pair equals the leakage of the tail (printed as "NET1 <V>"), the clock rises at 1 ps and the transient is
* the trapezoidal one of sar_cmp_q_ref.cir. This is the comparator as a clocked circuit finds itself at the clock edge when the reset phase has been long enough; the spec's rest puts
* net1 at max(VDP, VDN) - 0.35 V. Run: IHP_PDK=<checkout> IHP_OSDI=<osdi dir> ngspice -b sar_cmp_q_free.cir > sar_cmp_q_free.out    (ngspice-47)
* What it prints: "NET1 <V>", the operating point value of net1 with h = 16777; then, per run, after "RUN F <h> <sg>", tck, tfirst, tres, dpend and dnend as sar_cmp_q_ref.cir does.
.lib $IHP_PDK/ihp-sg13g2/libs.tech/ngspice/models/cornerMOSlv.lib mos_tt
Vdd vdd 0 1.5
Vdp vdp 0 0.75
Vdn vdn 0 0.75
.param tclk=200p
.param tfall=1
Bclk clkc 0 V = 1.5*min(max((time-{tclk})/1.6p,0),1)*(1-min(max((time-{tfall})/1.6p,0),1))
XM1 ap clkc vdd vdd sg13_lv_pmos w=3.0u l=0.45u ng=1 m=9
XM2 an clkc vdd vdd sg13_lv_pmos w=3.0u l=0.45u ng=1 m=9
XM3 ap vdn net1 0 sg13_lv_nmos w=1.0u l=0.45u ng=1 m=36
XM4 an vdp net1 0 sg13_lv_nmos w=1.0u l=0.45u ng=1 m=36
XM5 net1 clkc 0 0 sg13_lv_nmos w=1.0u l=0.45u ng=1 m=18
XM6 net2 dp vdd vdd sg13_lv_pmos w=3.0u l=0.45u ng=1 m=30
XM7 net3 dn vdd vdd sg13_lv_pmos w=3.0u l=0.45u ng=1 m=30
XM8 dp an net3 vdd sg13_lv_pmos w=3.0u l=0.45u ng=1 m=30
XM9 dn ap net2 vdd sg13_lv_pmos w=3.0u l=0.45u ng=1 m=30
XM10 dn dp 0 0 sg13_lv_nmos w=1.0u l=0.45u ng=1 m=12
XM11 dp dn 0 0 sg13_lv_nmos w=1.0u l=0.45u ng=1 m=12
XM12 dn n_clkc 0 0 sg13_lv_nmos w=1.0u l=0.45u ng=1 m=6
XM13 dp n_clkc 0 0 sg13_lv_nmos w=1.0u l=0.45u ng=1 m=6
XIP n_clkc clkc vdd vdd sg13_lv_pmos w=3.0u l=0.45u ng=1 m=1
XIN n_clkc clkc 0 0 sg13_lv_nmos w=1.0u l=0.45u ng=1 m=1
Cbdp dp 0 4f
Cbdn dn 0 4f
Bmx mx 0 V = max(v(dp),v(dn))
Bdiff diff 0 V = abs(v(dp)-v(dn))
.nodeset v(ap)=1.5 v(an)=1.5 v(net2)=1.5 v(net3)=1.5 v(dp)=0 v(dn)=0 v(n_clkc)=1.5 v(net1)=0.7
.temp 27
.options reltol=1e-8 vntol=1e-11 abstol=1e-13 itl4=200
.control
set num_threads=2
pre_osdi $IHP_OSDI/psp103.osdi
pre_osdi $IHP_OSDI/psp103_nqs.osdi
set numdgt=10
set noprintscale
alterparam tclk = 1p
reset
alter Vdp = 0.75 + 16777 / 16777216
alter Vdn = 0.75 - 16777 / 16777216
op
echo NET1
print v(net1)
foreach h 16777 4194 262
  foreach sg 1 -1
    alter Vdp = 0.75 + $sg * $h / 16777216
    alter Vdn = 0.75 - $sg * $h / 16777216
    tran 0.1p 3n 0 0.5p
    echo RUN F $h $sg
    meas tran tck when v(clkc)=0.75 rise=1
    meas tran tfirst when v(mx)=0.75 rise=1
    meas tran tres when v(diff)=0.75 rise=1
    meas tran dpend find v(dp) at=3n
    meas tran dnend find v(dn) at=3n
  end
end
.endc
.end
