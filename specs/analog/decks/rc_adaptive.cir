M0 RC low-pass, ngspice default adaptive transient
* specs/analog/decks/rc_adaptive.cir -- test data for specs/analog/bench.t27 (#10505). A plain netlist, no .control block.
* The same circuit and run as rc_fixed.cir, written as a user would write it: a PWL source and the default options
* (trapezoidal integration, reltol 1e-3, ngspice's own step control). tmax is its default, min(tstep, tstop/50) = 50 ns.
* IN = 1 V until 5000 ns and 0 V from 5050 ns: step 99 of the run ends at 5000 ns, step 100 at 5050 ns, and the source
* carries the value of the step's END point, as the backward Euler recurrence does. uic with IC=0 starts OUT at 0 V.
* Run: ngspice -b -r rc_adaptive.raw rc_adaptive.cir   (the raw file holds float64 values)
V1 in 0 PWL(0 1 5000n 1 5050n 0)
R1 in 1 1k
C1 1 0 1n IC=0
.tran 50n 10000n uic
.end
