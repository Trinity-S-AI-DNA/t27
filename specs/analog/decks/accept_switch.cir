IHP SG13G2 PSP103 bootstrapped tracking switch, DC input held through one clock pulse: tracking error, hold step, droop, corner mos_tt, 27 C
* specs/analog/decks/accept_switch.cir -- reference data for specs/analog/accept_sar.t27 (M5d, #11263, epic #10486). The tracking_switch cell of the golden SAR ADC netlist, ten
* transistors with the W, L and m of its devices (nmos 1.0 um / 0.45 um, pmos 3.0 um / 0.45 um, ng 1, m 1 -- facts of the circuit, none of its text), the inverter that makes
* the complement of the clock, the boost capacitor of 603.2 fF (cap_cmim 20 um x 20 um at the IHP PDK 21133f21: C = CJ L W + 2 CJSW (L + W), see sar_switch.t27) and the cell's seven
* 4 fF node capacitors, on the PSP103 of the IHP SG13G2 PDK, section mos_tt, 27 C. specs/analog/sar_switch.t27 is the SAME cell with the SQUARE LAW (MOSFET level 1); here it is
* the foundry's model, to see what the square law leaves out. Paths are NOT in this file: ngspice reads IHP_PDK and IHP_OSDI from the environment.
* Run: IHP_PDK=<checkout> IHP_OSDI=<osdi dir> ngspice -b accept_switch.cir    (ngspice-47)
* The run: the clock rises over 2 ns, stays at 1.5 V for 80 ns (the track phase) and falls over 2 ns; the period of the golden deck is 500 ns, so the hold lasts to 500 ns. Four copies of the
* cell share the clock, each with its own input held at a constant: 0.3 V and 1.2 V into 2 pF (the conditions of the external team's report of 2026-10-16: te_b1, te_b2) and 0.2 V and
* 1.3 V into 3930.2 fF (the conditions of sar_switch.t27: the DAC's top plate; te_a1, te_a2). The output load is the 4 fF of the cell plus the load named here. Each output starts 0.1 V under its input.
* What it prints (.meas, 6 digits; the tracking error is read as a difference so that it keeps its digits):
*   te_xx   V(out) - V(in) at 81.9 ns, the end of the track phase (the clock falls from 82 ns)
*   vo_f_xx V(out) at 81.9 ns; vo_h_xx at 86 ns, two ns after the fall ends: the hold step is vo_h - vo_f; vo_e_xx at 104 ns: the 20 ns droop of sar_switch.t27 is vo_e - vo_h;
*   vo_z_xx at 499 ns: the droop over the whole hold is vo_z - vo_h.
* Solver options: reltol 1e-6, vntol 1e-9, abstol 1e-13, gmin 1e-18 (no leak is added by the simulator), a step of at most 100 ps.
.lib $IHP_PDK/ihp-sg13g2/libs.tech/ngspice/models/cornerMOSlv.lib mos_tt
.subckt inv vin vdd vss vout
XMP vout vin vdd vdd sg13_lv_pmos w=3.0u l=0.45u ng=1 m=1
XMN vout vin vss vss sg13_lv_nmos w=1.0u l=0.45u ng=1 m=1
.ends
.subckt trk vdd vss vin vout clks
XM1 net1 clks vdd vdd sg13_lv_pmos w=3.0u l=0.45u ng=1 m=1
XM2 net1 clks net2 vss sg13_lv_nmos w=1.0u l=0.45u ng=1 m=1
XM3 net1 net3 net2 vss sg13_lv_nmos w=1.0u l=0.45u ng=1 m=1
XM4 net2 n_clks vss vss sg13_lv_nmos w=1.0u l=0.45u ng=1 m=1
XM5 vin net3 net2 vss sg13_lv_nmos w=1.0u l=0.45u ng=1 m=1
XM6 vout net3 vin vss sg13_lv_nmos w=1.0u l=0.45u ng=1 m=1
XM7 vdd net3 net4 net4 sg13_lv_pmos w=3.0u l=0.45u ng=1 m=1
XM8 net3 vdd net5 vss sg13_lv_nmos w=1.0u l=0.45u ng=1 m=1
XM9 net5 n_clks vss vss sg13_lv_nmos w=1.0u l=0.45u ng=1 m=1
XM10 net3 net1 net4 net4 sg13_lv_pmos w=3.0u l=0.45u ng=1 m=1
x1 clks vdd vss n_clks inv
C3 net2 net4 603.2f
C1 net4 0 4f
C2 vout 0 4f
C4 net1 0 4f
C6 net3 0 4f
C7 net5 0 4f
C8 net3 0 4f
C5 net2 0 4f
.ends
VDD vdd 0 1.5
VCLK clks 0 PULSE(0 1.5 0 2n 2n 80n 500n)
Via1 ina1 0 0.2
Via2 ina2 0 1.3
Vib1 inb1 0 0.3
Vib2 inb2 0 1.2
Xa1 vdd 0 ina1 outa1 clks trk
Xa2 vdd 0 ina2 outa2 clks trk
Xb1 vdd 0 inb1 outb1 clks trk
Xb2 vdd 0 inb2 outb2 clks trk
CLa1 outa1 0 3930.2f
CLa2 outa2 0 3930.2f
CLb1 outb1 0 2p
CLb2 outb2 0 2p
Bta1 tea1 0 V = v(outa1) - v(ina1)
Bta2 tea2 0 V = v(outa2) - v(ina2)
Btb1 teb1 0 V = v(outb1) - v(inb1)
Btb2 teb2 0 V = v(outb2) - v(inb2)
.ic v(outa1)=0.1 v(outa2)=1.2 v(outb1)=0.2 v(outb2)=1.1
.options temp=27 reltol=1e-6 vntol=1e-9 abstol=1e-13 gmin=1e-18 itl4=500
.tran 100p 500n 0 100p
.meas tran te_a1 find v(tea1) at=81.9n
.meas tran te_a2 find v(tea2) at=81.9n
.meas tran te_b1 find v(teb1) at=81.9n
.meas tran te_b2 find v(teb2) at=81.9n
.meas tran vo_f_a1 find v(outa1) at=81.9n
.meas tran vo_h_a1 find v(outa1) at=86n
.meas tran vo_e_a1 find v(outa1) at=104n
.meas tran vo_z_a1 find v(outa1) at=499n
.meas tran vo_f_a2 find v(outa2) at=81.9n
.meas tran vo_h_a2 find v(outa2) at=86n
.meas tran vo_e_a2 find v(outa2) at=104n
.meas tran vo_z_a2 find v(outa2) at=499n
.meas tran vo_f_b1 find v(outb1) at=81.9n
.meas tran vo_h_b1 find v(outb1) at=86n
.meas tran vo_e_b1 find v(outb1) at=104n
.meas tran vo_z_b1 find v(outb1) at=499n
.meas tran vo_f_b2 find v(outb2) at=81.9n
.meas tran vo_h_b2 find v(outb2) at=86n
.meas tran vo_e_b2 find v(outb2) at=104n
.meas tran vo_z_b2 find v(outb2) at=499n
.control
pre_osdi $IHP_OSDI/psp103.osdi
pre_osdi $IHP_OSDI/psp103_nqs.osdi
set num_threads=2
run
.endc
.end
