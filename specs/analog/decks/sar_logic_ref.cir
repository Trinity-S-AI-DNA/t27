SAR_logic and clock_gen of the golden SAR deck at transistor level, PSP103 tt at 50 C, ideal clks and Valid pulse trains
* specs/analog/decks/sar_logic_ref.cir -- reference data for specs/analog/sar_logic.t27 (M4d, #10754, epic #10486). The digital part of the golden SAR
* ADC deck (uberWAVE wp2-parser/golden/top.spice, GPL-2.0: fetched at run time, never vendored), at TRANSISTOR level with the IHP SG13G2 PSP103 model:
* x7 (SAR_logic: eleven dff, each four tgate + four nor + two inverter) and x4 (clock_gen: nor3, delay_cell, inverter), wired as the golden top wires
* them (D = VDD, Set = 0, the trim code A B C = 0 0 0, and the golden top's 4 fF on CK1, 8 fF on clkc, 12 fF on Valid). The comparator and the DAC
* are NOT here: Valid is an ideal source, and no CK net carries the DAC's load (the golden top hangs DAC_control_top and the bottom-plate logic on
* them), so the CK edges below are the sequencer's own. Everything but the two ideal sources is the deck's own subcircuits.
* Paths are NOT in this file: ngspice reads IHP_PDK (the IHP-Open-PDK checkout), IHP_OSDI (the directory with the compiled psp103.osdi and
* psp103_nqs.osdi) and SAR_GOLDEN_SUBCKTS (the subcircuit section of the golden deck, made at run time:
*   sed -n '/^.subckt tracking_switch/,$p' top.spice | grep -v -i -E '^\.(end|global)([[:space:]]|$)' > $SAR_GOLDEN_SUBCKTS )  from the environment.
* Run: IHP_PDK=<checkout> IHP_OSDI=<osdi dir> SAR_GOLDEN_SUBCKTS=<file> ngspice -b sar_logic_ref.cir   (ngspice-47)
* Stimulus: clks is high from 0.5 ns to 31.5 ns (the reset, 50 % points) and low after; Valid rises (50 %) at 80.1 ns and every 40 ns after,
* eleven pulses, 20 ns wide, falling (50 %) at 100.3 ns and every 40 ns after, edges 0.2 ns. Eleven pulses are one SAR conversion: CK11 .. CK1 rise one
* per pulse. It prints one line per measure, <name> = <seconds>: tclksf (clks falls), tv<i> / tvf<i> (Valid rises / falls, i = 1 .. 11),
* tck<k> (CK<k> rises, k = 11 .. 1), tcr<i> / tcf<i> (clkc rises / falls, i = 1 .. 11). All at 0.75 V, half of the supply.
.lib $IHP_PDK/ihp-sg13g2/libs.tech/ngspice/models/cornerMOSlv.lib mos_tt
.include $SAR_GOLDEN_SUBCKTS
VDD vdd 0 1.5
Vclks clks 0 PULSE(0 1.5 0n 1n 1n 30n 1u)
Vvalid valid 0 PULSE(0 1.5 80n 0.2n 0.2n 20n 40n)
Vd d 0 1.5
Vset set 0 0
Va a 0 0
Vb b 0 0
Vc c 0 0
x7 ck3 ck11 ck7 ck2 ck6 ck10 ck1 ck9 ck5 ck8 ck4 vdd 0 d valid set clks SAR_logic
x4 vdd clkc 0 clks valid ck1 a b c clock_gen
Cvalid valid 0 12f
Cck1 ck1 0 4f
Cclkc clkc 0 8f
.temp 50
.options reltol=1e-3
.tran 5p 520n 0 50p
.control
pre_osdi $IHP_OSDI/psp103.osdi
pre_osdi $IHP_OSDI/psp103_nqs.osdi
set numdgt=7
run
meas tran tclksf when v(clks)=0.75 fall=1
meas tran tv1 when v(valid)=0.75 rise=1
meas tran tv2 when v(valid)=0.75 rise=2
meas tran tv3 when v(valid)=0.75 rise=3
meas tran tv4 when v(valid)=0.75 rise=4
meas tran tv5 when v(valid)=0.75 rise=5
meas tran tv6 when v(valid)=0.75 rise=6
meas tran tv7 when v(valid)=0.75 rise=7
meas tran tv8 when v(valid)=0.75 rise=8
meas tran tv9 when v(valid)=0.75 rise=9
meas tran tv10 when v(valid)=0.75 rise=10
meas tran tv11 when v(valid)=0.75 rise=11
meas tran tvf1 when v(valid)=0.75 fall=1
meas tran tvf2 when v(valid)=0.75 fall=2
meas tran tvf3 when v(valid)=0.75 fall=3
meas tran tvf4 when v(valid)=0.75 fall=4
meas tran tvf5 when v(valid)=0.75 fall=5
meas tran tvf6 when v(valid)=0.75 fall=6
meas tran tvf7 when v(valid)=0.75 fall=7
meas tran tvf8 when v(valid)=0.75 fall=8
meas tran tvf9 when v(valid)=0.75 fall=9
meas tran tvf10 when v(valid)=0.75 fall=10
meas tran tvf11 when v(valid)=0.75 fall=11
meas tran tck11 when v(ck11)=0.75 rise=LAST
meas tran tck10 when v(ck10)=0.75 rise=LAST
meas tran tck9 when v(ck9)=0.75 rise=LAST
meas tran tck8 when v(ck8)=0.75 rise=LAST
meas tran tck7 when v(ck7)=0.75 rise=LAST
meas tran tck6 when v(ck6)=0.75 rise=LAST
meas tran tck5 when v(ck5)=0.75 rise=LAST
meas tran tck4 when v(ck4)=0.75 rise=LAST
meas tran tck3 when v(ck3)=0.75 rise=LAST
meas tran tck2 when v(ck2)=0.75 rise=LAST
meas tran tck1 when v(ck1)=0.75 rise=LAST
meas tran tcr1 when v(clkc)=0.75 rise=1
meas tran tcr2 when v(clkc)=0.75 rise=2
meas tran tcr3 when v(clkc)=0.75 rise=3
meas tran tcr4 when v(clkc)=0.75 rise=4
meas tran tcr5 when v(clkc)=0.75 rise=5
meas tran tcr6 when v(clkc)=0.75 rise=6
meas tran tcr7 when v(clkc)=0.75 rise=7
meas tran tcr8 when v(clkc)=0.75 rise=8
meas tran tcr9 when v(clkc)=0.75 rise=9
meas tran tcr10 when v(clkc)=0.75 rise=10
meas tran tcr11 when v(clkc)=0.75 rise=11
meas tran tcf1 when v(clkc)=0.75 fall=1
meas tran tcf2 when v(clkc)=0.75 fall=2
meas tran tcf3 when v(clkc)=0.75 fall=3
meas tran tcf4 when v(clkc)=0.75 fall=4
meas tran tcf5 when v(clkc)=0.75 fall=5
meas tran tcf6 when v(clkc)=0.75 fall=6
meas tran tcf7 when v(clkc)=0.75 fall=7
meas tran tcf8 when v(clkc)=0.75 fall=8
meas tran tcf9 when v(clkc)=0.75 fall=9
meas tran tcf10 when v(clkc)=0.75 fall=10
meas tran tcf11 when v(clkc)=0.75 fall=11
.endc
.end
