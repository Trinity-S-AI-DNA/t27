SAR ADC dynamic comparator on PSP103 with every bulk tied to its source, charge swamped by 1e6: backward Euler on a fixed 0.1 us grid
* specs/analog/decks/sar_cmp_psp_r2b.cir -- reference data for specs/analog/sar_comparator_psp.t27 (analog M4b-psp, #10856, epic #10486). A netlist plus a
* .control block that prints the numbers. The same run as sar_cmp_psp_r2.cir (read its header for the scale, the inputs, the clock, the start, the
* integration options and the printed rows) on the same thirteen transistors and the inverter x1, with ONE change: the bulk of every device is tied to its own
* source, which is what a 2-D table Id(Vgs, Vds) of M3b models. The golden deck ties the NMOS bulks to ground and the PMOS bulks to VDD, so the input pair
* XM3, XM4 (source net1, 0.15 .. 0.4 V above its bulk) and the PMOS XM8, XM9 (sources net3, net2, below their bulk) carry a body effect which the
* tables cannot have; the difference between this deck and sar_cmp_psp_r2.cir is that body effect and nothing else. W, L and m are the golden deck's
* (facts of the circuit); the text of the golden deck is not copied. The deck reads no golden file: IHP_PDK and IHP_OSDI only.
* Run: IHP_PDK=<checkout> IHP_OSDI=<osdi dir> ngspice -b sar_cmp_psp_r2b.cir > sar_cmp_psp_r2b.out    (ngspice-47)
* Second part, "MM <m4> <d>": the input pair made unequal, XM4 (the device whose gate is VDP) at m = 35 and 34 instead of 36, with VDP - VDN = d units of
* 2^-24 V; it prints dpend and dnend only. The flip point of the unequal pair is the d at which the winner changes: dn wins below it, dp above. The
* four d are the pairs of neighbours found by bisection (a 2-unit bracket): 71579 and 71581 for m = 35, 145772 and 145774 for m = 34.
.lib $IHP_PDK/ihp-sg13g2/libs.tech/ngspice/models/cornerMOSlv.lib mos_tt
Vdd vdd 0 1.5
Vdp vdp 0 0.75
Vdn vdn 0 0.75
Bclk clkc 0 V = 1.5*min(max(nint(time/1e-7)-10,0),16)/16
XM1 xc.ap clkc vdd vdd sg13_lv_pmos w=3.0u l=0.45u ng=1 m=9
XM2 xc.an clkc vdd vdd sg13_lv_pmos w=3.0u l=0.45u ng=1 m=9
XM3 xc.ap vdn xc.net1 xc.net1 sg13_lv_nmos w=1.0u l=0.45u ng=1 m=36
XM4 xc.an vdp xc.net1 xc.net1 sg13_lv_nmos w=1.0u l=0.45u ng=1 m={m4}
XM5 xc.net1 clkc 0 0 sg13_lv_nmos w=1.0u l=0.45u ng=1 m=18
XM6 xc.net2 dp vdd vdd sg13_lv_pmos w=3.0u l=0.45u ng=1 m=30
XM7 xc.net3 dn vdd vdd sg13_lv_pmos w=3.0u l=0.45u ng=1 m=30
XM10 dn dp 0 0 sg13_lv_nmos w=1.0u l=0.45u ng=1 m=12
XM11 dp dn 0 0 sg13_lv_nmos w=1.0u l=0.45u ng=1 m=12
XM12 dn xc.n_clkc 0 0 sg13_lv_nmos w=1.0u l=0.45u ng=1 m=6
XM13 dp xc.n_clkc 0 0 sg13_lv_nmos w=1.0u l=0.45u ng=1 m=6
XM8 dp xc.an xc.net3 xc.net3 sg13_lv_pmos w=3.0u l=0.45u ng=1 m=30
XM9 dn xc.ap xc.net2 xc.net2 sg13_lv_pmos w=3.0u l=0.45u ng=1 m=30
XIP xc.n_clkc clkc vdd vdd sg13_lv_pmos w=3.0u l=0.45u ng=1 m=1
XIN xc.n_clkc clkc 0 0 sg13_lv_nmos w=1.0u l=0.45u ng=1 m=1
Cap xc.ap 0 4n
Can xc.an 0 4n
Cn1 xc.net1 0 6n
Cn2 xc.net2 0 2n
Cn3 xc.net3 0 2n
Cdp dp 0 4n
Cdn dn 0 4n
Cnc xc.n_clkc 0 2n
Bmx mx 0 V = max(v(dp),v(dn))
Bdiff diff 0 V = abs(v(dp)-v(dn))
.ic v(xc.ap)=1.5 v(xc.an)=1.5 v(xc.net1)=0.4009999632835388 v(xc.net2)=1.5 v(xc.net3)=1.5 v(dp)=0 v(dn)=0 v(xc.n_clkc)=1.5
.param m4=36
.temp 50
.options method=gear maxord=1 trtol=1e7 reltol=1e-7 vntol=1e-10 abstol=1e-12 gmin=1e-12 itl4=200
.control
pre_osdi $IHP_OSDI/psp103.osdi
pre_osdi $IHP_OSDI/psp103_nqs.osdi
set numdgt=10
set noprintscale
foreach h 16777 4194 1049 262 84 8 1
  foreach sg 1 -1
    alter Vdp = 0.75 + $sg * $h / 16777216
    alter Vdn = 0.75 - $sg * $h / 16777216
    tran 100n 15.5u 0 100n uic
    echo RUN $h $sg
    meas tran tck when v(clkc)=0.75 rise=1
    meas tran tfirst when v(mx)=0.75 rise=1
    meas tran tres when v(diff)=0.75 rise=1
    meas tran dpend find v(dp) at=15.5u
    meas tran dnend find v(dn) at=15.5u
    foreach r 39 59 71 79 87 95 109 149
      echo ROW $r
      print time[$r] v(xc.ap)[$r] v(xc.an)[$r] v(xc.net1)[$r] v(xc.net2)[$r] v(xc.net3)[$r] v(dp)[$r] v(dn)[$r] v(xc.n_clkc)[$r]
    end
  end
end
alterparam m4 = 35
reset
foreach d 71579 71581
  alter Vdp = 0.75 + ($d) / 2 / 16777216
  alter Vdn = 0.75 - ($d) / 2 / 16777216
  tran 100n 15.5u 0 100n uic
  echo MM 35 $d
  meas tran dpend find v(dp) at=15.5u
  meas tran dnend find v(dn) at=15.5u
end
alterparam m4 = 34
reset
foreach d 145772 145774
  alter Vdp = 0.75 + ($d) / 2 / 16777216
  alter Vdn = 0.75 - ($d) / 2 / 16777216
  tran 100n 15.5u 0 100n uic
  echo MM 34 $d
  meas tran dpend find v(dp) at=15.5u
  meas tran dnend find v(dn) at=15.5u
end
.endc
.end
