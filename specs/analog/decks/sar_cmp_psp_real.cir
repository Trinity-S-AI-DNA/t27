SAR ADC dynamic comparator on PSP103, real device charges, 50 C: the golden comparator bare and with its own loads
* specs/analog/decks/sar_cmp_psp_real.cir -- reference data for specs/analog/sar_comparator_psp.t27 (analog M4b-psp, #10856, epic #10486). A netlist plus a
* .control block that prints the numbers.
* Circuits, side by side in one netlist (they share only the two input sources, which are ideal), both from the uberWAVE golden SAR deck
* (wp2-parser/golden/top.spice; GPL-2.0, fetched at run time, never vendored):
*   Xb   the subcircuit dynamic_comparator with 4 fF on dp and dn (bdp, bdn): the latch alone, the circuit of the spec;
*   Xtop the subcircuit dynamic_comparator_top: the same latch, 4 fF on each output, an inverter on each (x5, x6), 4 fF on each inverter output
*        and the NAND of the two inverter outputs, "Valid". The converter's comparator, with the loads it has there.
* PSP103 (IHP-Open-PDK 21133f219b1a6da10d803e345761e77415ceff40, cornerMOSlv.lib mos_tt, through OSDI), 50 C, with ALL its charge: the gate, overlap
* and junction capacitance of every device. Nothing is scaled: this is the circuit as the converter has it, with an ideal 1.6 ps clock (the spec's) in
* place of the delay-cell clkc, and the inputs held. The subcircuit text comes from the file named by the environment variable SAR_GOLDEN_SUBCKTS
* (the sed line is in the header of sar_cmp_psp_r2.cir); IHP_PDK and IHP_OSDI as in all the PSP103 decks.
* Run: IHP_PDK=<checkout> IHP_OSDI=<osdi dir> SAR_GOLDEN_SUBCKTS=<file> ngspice -b sar_cmp_psp_real.cir > sar_cmp_psp_real.out    (ngspice-47)
* Inputs: VDD 1.5 V, common mode 0.75 V. First list: VDP = 0.75 + sg h / 2^24 and VDN = 0.75 - sg h / 2^24 for h in units of 2^-24 V, sg = +1 or -1, as in
* sar_cmp_psp_r2.cir. Second list ("SCAN d"): VDP - VDN = d units, centred on 0.75 V, d from -2700 to -2400, around the flip point of Xtop. The clock is 0
* until 200 ps, then rises over 1.6 ps (its 50 % point at 200.8 ps). Start: .ic with uic, the spec's rest (ap = an = net2 = net3 = n_clkc = 1.5 V,
* dp = dn = 0, net1 = 0.4009999632835388 V) and the inverters' and NAND's outputs at their logic values; nodes not named start at 0 and settle in the
* 200 ps before the clock. Integration: ngspice's default (trapezoidal), the step capped at 0.5 ps; reltol 1e-8, vntol 1e-11, abstol 1e-13 (the flip
* point of Xtop moved by 10 units between reltol 1e-6 and 1e-8: the tolerance is part of the number).
* What it prints, per run, after "RUN <h> <sg>" or "SCAN <d>": tck, the clock through 0.75 V; tfirst, the first of dp and dn of Xb through 0.75 V; tres,
* |dp - dn| of Xb through 0.75 V; tvalid, Valid through 0.75 V (rising; only in the first list); dpend and dnend, dp and dn of Xb at 3 ns; tdpend and
* tdnend, the same for Xtop.
.lib $IHP_PDK/ihp-sg13g2/libs.tech/ngspice/models/cornerMOSlv.lib mos_tt
.include $SAR_GOLDEN_SUBCKTS
Vdd vdd 0 1.5
Vdp vdp 0 0.75
Vdn vdn 0 0.75
Bclk clkc 0 V = 1.5*min(max((time-200p)/1.6p,0),1)
Xb vdp vdn clkc vdd 0 bdp bdn dynamic_comparator
Cbdp bdp 0 4f
Cbdn bdn 0 4f
Xtop vocp vocn valid vdp vdn clkc vdd 0 dynamic_comparator_top
Bmx mx 0 V = max(v(bdp),v(bdn))
Bdiff diff 0 V = abs(v(bdp)-v(bdn))
.ic v(xb.ap)=1.5 v(xb.an)=1.5 v(xb.net1)=0.4009999632835388 v(xb.net2)=1.5 v(xb.net3)=1.5 v(bdp)=0 v(bdn)=0 v(xb.n_clkc)=1.5
+ v(xtop.x1.ap)=1.5 v(xtop.x1.an)=1.5 v(xtop.x1.net1)=0.4009999632835388 v(xtop.x1.net2)=1.5 v(xtop.x1.net3)=1.5 v(xtop.dp)=0 v(xtop.dn)=0 v(xtop.x1.n_clkc)=1.5
+ v(vocp)=1.5 v(vocn)=1.5 v(valid)=0
.temp 50
.options reltol=1e-8 vntol=1e-11 abstol=1e-13 itl4=200
.control
pre_osdi $IHP_OSDI/psp103.osdi
pre_osdi $IHP_OSDI/psp103_nqs.osdi
set numdgt=10
set noprintscale
foreach h 16777 4194 1049 262 84 8 1
  foreach sg 1 -1
    alter Vdp = 0.75 + $sg * $h / 16777216
    alter Vdn = 0.75 - $sg * $h / 16777216
    tran 0.1p 3n 0 0.5p uic
    echo RUN $h $sg
    meas tran tck when v(clkc)=0.75 rise=1
    meas tran tfirst when v(mx)=0.75 rise=1
    meas tran tres when v(diff)=0.75 rise=1
    meas tran tvalid when v(valid)=0.75 rise=1
    meas tran dpend find v(bdp) at=3n
    meas tran dnend find v(bdn) at=3n
    meas tran tdpend find v(xtop.dp) at=3n
    meas tran tdnend find v(xtop.dn) at=3n
  end
end
foreach d -2700 -2600 -2571 -2570 -2540 -2400
  alter Vdp = 0.75 + ($d) / 2 / 16777216
  alter Vdn = 0.75 - ($d) / 2 / 16777216
  tran 0.1p 3n 0 0.5p uic
  echo SCAN $d
  meas tran dpend find v(bdp) at=3n
  meas tran dnend find v(bdn) at=3n
  meas tran tdpend find v(xtop.dp) at=3n
  meas tran tdnend find v(xtop.dn) at=3n
end
.endc
.end
