IHP SG13G2 inverter, 500 fF, converged reference (trapezoidal rule, steps of at most 1 ps), corner mos_tt
* specs/analog/decks/psp103_inv_fine_500f.cir -- reference data for specs/analog/mos_psp103.t27 (M3b, #10516, epic #10486). A netlist plus
* a .control block that prints two numbers.
* The circuit of psp103_inv_be_500f.cir run with the step held to 1 ps (1/100 of the 100 ps grid), edges as ideal steps at t = 100 ps and
* t = 20.1 ns (the starts of steps 0 and 200 of the fixed-step run).
* Paths are NOT in this file: ngspice reads IHP_PDK and IHP_OSDI from the environment (see psp103_tab_tt.cir).
* Run: IHP_PDK=<checkout> IHP_OSDI=<osdi dir> ngspice -b psp103_inv_fine_500f.cir    (ngspice-47)
* What it prints (ngspice .meas, 6 digits, in s): tplh and tphl, the 0.75 V crossings; the delays are these minus 100 ps and minus 20.1 ns.
.lib $IHP_PDK/ihp-sg13g2/libs.tech/ngspice/models/cornerMOSlv.lib mos_tt
VDD vdd 0 1.5
Bin in 0 V = 1.5*(1-u(time-100p)+u(time-20.1n))
XIP out in vdd vdd sg13_lv_pmos w=3.0u l=0.45u ng=1 m=1
XIN out in 0 0 sg13_lv_nmos w=1.0u l=0.45u ng=1 m=1
CL out 0 500f
.temp 27
.options reltol=1e-6 vntol=1e-9 abstol=1e-12 itl4=200
.tran 100p 40.4n 0 1p
.meas tran tplh when v(out)=0.75 rise=1
.meas tran tphl when v(out)=0.75 fall=1
.control
pre_osdi $IHP_OSDI/psp103.osdi
pre_osdi $IHP_OSDI/psp103_nqs.osdi
run
.endc
.end
