IHP SG13G2 inverter, 10 pF, converged reference (trapezoidal rule, steps of at most 20 ps), corner mos_tt
* specs/analog/decks/psp103_inv_fine.cir -- reference data for specs/analog/mos_psp103.t27 (M3b, #10516, epic #10486). A netlist plus a
* .control block that prints the numbers.
* The circuit of psp103_inv_be.cir (inverter of the uberWAVE golden SAR deck, 10 pF, mos_tt, 27 C, IHP-Open-PDK commit 21133f21), run
* the way ngspice runs by default: trapezoidal rule, local-error step control, but with the step held to 20 ps (1/100 of the 2 ns grid) so
* that the grid of the fixed-step run is resolved a hundred times over. This is the continuous circuit as far as the spec needs it; the
* difference between psp103_inv_be.cir and this run is the DISCRETIZATION error of backward Euler at dt = 2 ns.
* The input is the same two edges as an ideal step: Vdd to 0 V at t = 2 ns (the start of step 0 of the fixed-step run, whose input is
* evaluated at the end of the step) and 0 V to Vdd at t = 402 ns (the start of step 200).
* Paths are NOT in this file: ngspice reads IHP_PDK and IHP_OSDI from the environment (see psp103_tab_tt.cir).
* Run: IHP_PDK=<checkout> IHP_OSDI=<osdi dir> ngspice -b psp103_inv_fine.cir > psp103_inv_fine.out    (ngspice-47)
* What it prints. tplh and tphl: the times at which the output crosses 0.75 V rising and falling (ngspice .meas, 6 digits, in s); the
* delays are these minus 2 ns and minus 402 ns. Between "BEGIN tran_fine" and "END tran_fine", 401 rows "<index> TAB <y>": the output in units
* of 2^-24 V, resampled by linearize onto the 2 ns grid, at t = 2 ns (row 0, at rest), 4 ns, ... 802 ns (row 400): the rows of the fixed-step
* run, one for one. tstop is two steps past the last row used.
.lib $IHP_PDK/ihp-sg13g2/libs.tech/ngspice/models/cornerMOSlv.lib mos_tt
VDD vdd 0 1.5
Bin in 0 V = 1.5*(1-u(time-2n)+u(time-402n))
XIP out in vdd vdd sg13_lv_pmos w=3.0u l=0.45u ng=1 m=1
XIN out in 0 0 sg13_lv_nmos w=1.0u l=0.45u ng=1 m=1
CL out 0 10p
.temp 27
.options reltol=1e-6 vntol=1e-9 abstol=1e-12 itl4=200
.tran 2n 804n 0 20p
.meas tran tplh when v(out)=0.75 rise=1
.meas tran tphl when v(out)=0.75 fall=1
.control
pre_osdi $IHP_OSDI/psp103.osdi
pre_osdi $IHP_OSDI/psp103_nqs.osdi
set numdgt=10
set noprintscale
run
linearize v(out)
let y = nint(v(out) * 16777216)
let ys = y[1,401]
echo BEGIN tran_fine
print ys
echo END tran_fine
.endc
.end
