The golden SAR ADC's sine run, the comparator's clock edge at six decisions: the tail node and the drain of the input pair before and through the edge (M4e-kick, #10942)
* specs/analog/decks/sar_kick_late.cir -- sar_off_base.cir (the golden SAR ADC deck of uberWAVE, wp2-parser/golden/top.spice, GPL-2.0: fetched at run time, never vendored; its subcircuits
* come from the run-time file SAR_GOLDEN_SUBCKTS, made as in sar_off_base.cir) with nothing changed in the circuit and a different readout: the golden sine (sar_amp 0.6, the first two conversions,
* 1.1 us) and, at the clock edge of six of its 22 decisions, the waves that sar_kick_edge.cir reads at the first decision with the two gates on ideal sources: the tail node net1 and the drain ap of
* the comparator's input pair, and the plates vdp and vdn, 67 samples 0.1 ns apart. The edge is clkc rising through 0.1 V (tcb) and through 0.75 V (tcc); sample k is at (j0 + 2 k) * 50 ps
* of the 50 ps grid that `linearize` makes, j0 = floor(tcb / 50 ps) - 30, that is 1.5 ns to 1.55 ns before the 0.1 V crossing, to 5.05 ns after it. The six are the clkc rises 1, 10, 11
* (decisions 0, 9 and 10 of the first conversion) and 12, 21, 22 (the same of the second); the first of each conversion has the sine's plates settled for 14 ns, the last two have nine and ten
* bottom plates moved. Like sar_kick_edge.cir this is the comparator's own history (what net1 and ap do before and through the edge), read where it happens, and sar_kick_net.t27 puts it
* through the same charge tables.
* Paths are NOT in this file: IHP_PDK (the IHP-Open-PDK checkout, commit 21133f21), IHP_OSDI (the directory with the compiled psp103.osdi, psp103_nqs.osdi, r3_cmc.osdi, mosvar.osdi,
* cap_cmomi.osdi, cap_cmomf.osdi) and SAR_GOLDEN_SUBCKTS, in the environment. Run: IHP_PDK=<checkout> IHP_OSDI=<osdi dir> SAR_GOLDEN_SUBCKTS=<file> ngspice -b sar_kick_late.cir   (ngspice-47, the
* transient of 1.1 us at 50 ps is the long part of it: minutes on a few cores). It prints, between BEGIN late and END late, per window: the decision's clkc rise number rr, the crossing times
* tcb and tcc in seconds, j0, the plates' difference vdp - vdn at the 0.1 V crossing (vpt - vnt, to compare with D of sar_kick.t27's DEC_D), and the four waves n1w, apw, vpw, vnw.
.param dmv=0
.param amp=0.6
.lib $IHP_PDK/ihp-sg13g2/libs.tech/ngspice/models/cornerMOSlv.lib mos_tt
.lib $IHP_PDK/ihp-sg13g2/libs.tech/ngspice/models/cornerCAP.lib cap_typ
.include $SAR_GOLDEN_SUBCKTS
* supplies, trim code A B C = 0 0 0, the common mode, the sampling clock and the differential sine input
VDD4 vdda 0 1.5
VDD6 vdd 0 1.5
VDD7 vcm 0 0.75
V2 c 0 0
V5 b 0 0
V6 a 0 0
VDD1 vss 0 0
VCMS net2 0 0.75
VCLKS clks 0 PULSE(0 1.5 0n 2n 2n 80n 500n)
VSP net2 vinp sin({-dmv*0.5e-3} {amp} 62.5k)
VSN vinn net2 sin({-dmv*0.5e-3} {amp} 62.5k)
* the two tracking switches, the comparator, the SAR logic and the clock generator
x1 vdda 0 vinn vdn clks tracking_switch
x2 vdda 0 vinp vdp clks tracking_switch
x3 vocp vocn valid vdp vdn clkc vdd 0 dynamic_comparator_top
x7 ck3 ck11 ck7 ck2 ck6 ck10 ck1 ck9 ck5 ck8 ck4 vdd 0 vdd valid 0 clks SAR_logic
x4 vdd clkc 0 clks valid ck1 a b c clock_gen
* the 4 fF loads the golden top hangs on the top plates and on the control nets
C3 vdp 0 4f
C4 vdn 0 4f
C5 vdp 0 4f
C6 vdn 0 4f
C7 vinp 0 4f
C8 vinn 0 4f
C9 clkc 0 4f
C10 vocp 0 4f
C11 valid 0 4f
C12 vocn 0 4f
C13 clkc 0 4f
C14 clks 0 4f
C15 valid 0 4f
C16 ck1 0 4f
C17 a 0 4f
C18 b 0 4f
C19 c 0 4f
C20 clks 0 4f
C21 valid 0 4f
C22 vdd 0 4f
* the bottom-plate drivers (every stage decides on vocn), then the negated copy of each bit for the N half
x5 vdd bit_10 vocn 0 ck11 vcm out_11 0 0 clks bit_9 vocn ck10 out_10 bit_8 vocn ck9 out_9 bit_7 vocn ck8 out_8 bit_6 vocn
+ ck7 out_7 bit_5 vocn ck6 out_6 bit_4 vocn ck5 out_5 bit_3 vocn ck4 out_4 bit_2 vocn ck3 out_3 bit_1 vocn ck2 out_2 bit_0 vocn ck1
+ out_1 DAC_control_top
x6 vdd vss ck11 bit_10 bit_10_n neg_bottom_plate_logic
x8 vdd vss ck6 bit_5 bit_5_n neg_bottom_plate_logic
x9 vdd vss ck10 bit_9 bit_9_n neg_bottom_plate_logic
x10 vdd vss ck5 bit_4 bit_4_n neg_bottom_plate_logic
x11 vdd vss ck9 bit_8 bit_8_n neg_bottom_plate_logic
x12 vdd vss ck4 bit_3 bit_3_n neg_bottom_plate_logic
x13 vdd vss ck8 bit_7 bit_7_n neg_bottom_plate_logic
x14 vdd vss ck3 bit_2 bit_2_n neg_bottom_plate_logic
x15 vdd vss ck7 bit_6 bit_6_n neg_bottom_plate_logic
x16 vdd vss ck2 bit_1 bit_1_n neg_bottom_plate_logic
* the deck's own output adder: V(out) = 1.5 V code / 2048 with the bits at 0 / 1.5 V
E1 out net12 out_11 0 0.5
E2 net12 net11 out_10 0 0.25
E3 net11 net10 out_9 0 0.125
E4 net10 net9 out_8 0 0.0625
E5 net9 net8 out_7 0 0.03125
E6 net8 net7 out_6 0 0.015625
E7 net7 net6 out_5 0 0.0078125
E8 net6 net5 out_4 0 0.00390625
E9 net5 net4 out_3 0 0.001953125
E10 net4 net3 out_2 0 0.0009765625
E11 net3 0 out_1 0 0.00048828125
* the two capacitive DAC halves: the N half on VDN with the negated bits, the P half on VDP
x17 vdn bit_3_n bit_8_n bit_5_n bit_6_n bit_7_n bit_4_n bit_9_n bit_10_n bit_2_n bit_1_n Diff_cap_DAC
x18 vdp bit_3 bit_8 bit_5 bit_6 bit_7 bit_4 bit_9 bit_10 bit_2 bit_1 Diff_cap_DAC
.ic v(x1.net1)=0
.ic v(x1.net2)=0
.nodeset v(x1.net2)=0
.ic v(x1.net3)=0
.ic v(x2.net1)=0
.ic v(x2.net2)=0
.ic v(x2.net3)=0
.ic v(x17.net1)=0
.ic v(x18.net1)=0
.ic v(vdp)=0
.ic v(vdn)=0
.options temp=50
.options klu
.save v(vdp) v(vdn) v(clkc) v(x3.x1.ap) v(x3.x1.net1)
.control
pre_osdi $IHP_OSDI/psp103.osdi
pre_osdi $IHP_OSDI/psp103_nqs.osdi
pre_osdi $IHP_OSDI/r3_cmc.osdi
pre_osdi $IHP_OSDI/mosvar.osdi
pre_osdi $IHP_OSDI/cap_cmomi.osdi
pre_osdi $IHP_OSDI/cap_cmomf.osdi
set num_threads=2
tran 0.05n 1.1u
linearize v(clkc) v(x3.x1.net1) v(x3.x1.ap) v(vdp) v(vdn)
set numdgt=8
set noprintscale
echo BEGIN late
foreach rr 1 10 11 12 21 22
  meas tran tcb when v(clkc)=0.1 rise=$rr
  meas tran tcc when v(clkc)=0.75 rise=$rr
  meas tran vpt find v(vdp) when v(clkc)=0.1 rise=$rr
  meas tran vnt find v(vdn) when v(clkc)=0.1 rise=$rr
  let j0 = floor(tcb / 5e-11) - 30
  let n1w = unitvec(67)
  let apw = unitvec(67)
  let vpw = unitvec(67)
  let vnw = unitvec(67)
  let k = 0
  while k < 67
    let j = j0 + 2*k
    let n1w[k] = v(x3.x1.net1)[j]
    let apw[k] = v(x3.x1.ap)[j]
    let vpw[k] = v(vdp)[j]
    let vnw[k] = v(vdn)[j]
    let k = k + 1
  end
  echo WINDOW $rr
  print tcb tcc j0 vpt vnt
  print n1w apw vpw vnw
end
echo END late
.endc
.end
