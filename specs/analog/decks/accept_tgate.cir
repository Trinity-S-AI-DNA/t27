IHP SG13G2 transmission gate conducting, DC: resistance over the output level, corner mos_tt, 27 C
* specs/analog/decks/accept_tgate.cir -- reference data for specs/analog/mos_psp103_gates.t27 and its use in specs/analog/accept_sar.t27 (M5d, #11263, epic #10486).
* The tgate of the golden SAR ADC netlist (a pmos 3.0 um / 0.45 um with its bulk on the supply, an nmos 1.0 um / 0.45 um with its bulk on ground; ng 1, m 1 -- facts of the circuit,
* none of its text) conducting: pmos gate 0 V, nmos gate 1.5 V. The input is held 10 mV above the output through a behavioural source whose branch current is the tgate's
* current, the output is swept from 0.10 V to 1.40 V in steps of 50 mV (27 points), and R = 10 mV / I, the measurement of sar_off_ron.cir at 27 C. Model: IHP SG13G2 PSP103 of
* IHP-Open-PDK 21133f21, section mos_tt. Paths are NOT in this file: ngspice reads IHP_PDK and IHP_OSDI from the environment.
* Run: IHP_PDK=<checkout> IHP_OSDI=<osdi dir> ngspice -b accept_tgate.cir    (ngspice-47)
* What it prints (ohm, 12 digits), between BEGIN and END:
*   rtg     the real cell: the nmos source is the output, its bulk is on ground, so its source-to-bulk voltage is the output level; the pmos source is the input, its bulk on the supply,
*           so its source-to-bulk voltage is 1.5 V minus the input. The BODY EFFECT is in it.
*   rnb     the same two devices with each bulk tied to its own source (the nmos bulk to the output, the pmos bulk to the input): the condition the current tables of
*           mos_psp103_data.t27 were made under (source and bulk on the same rail), so what the table model should reproduce if the body effect is what separates it from rtg.
* Solver options: reltol 1e-9, vntol 1e-12, abstol 1e-15; the simulator's default gmin (1e-12 S: 1e-7 of a 7 uA current), itl1 500.
.lib $IHP_PDK/ihp-sg13g2/libs.tech/ngspice/models/cornerMOSlv.lib mos_tt
.subckt tgate clk nclk in out vdd vss
XM1 out clk in vdd sg13_lv_pmos w=3.0u l=0.45u ng=1 m=1
XM2 in nclk out vss sg13_lv_nmos w=1.0u l=0.45u ng=1 m=1
.ends
.subckt tgate_nb clk nclk in out
XM1 out clk in in sg13_lv_pmos w=3.0u l=0.45u ng=1 m=1
XM2 in nclk out out sg13_lv_nmos w=1.0u l=0.45u ng=1 m=1
.ends
VDD vdd 0 1.5
V0 l0 0 0
V1 l1 0 1.5
VOUT tout 0 0.1
BIN tin 0 V = v(tout) + 0.01
Xon l0 l1 tin tout vdd 0 tgate
BIN2 tin2 0 V = v(tout) + 0.01
Xnb l0 l1 tin2 tout tgate_nb
.options temp=27 reltol=1e-9 vntol=1e-12 abstol=1e-15 itl1=500
.control
pre_osdi $IHP_OSDI/psp103.osdi
pre_osdi $IHP_OSDI/psp103_nqs.osdi
set num_threads=2
set numdgt=12
dc vout 0.1 1.4 0.05
let rtg = 0.01 / abs(i(bin))
let rnb = 0.01 / abs(i(bin2))
echo BEGIN ron
print rtg rnb
echo END ron
.endc
.end
