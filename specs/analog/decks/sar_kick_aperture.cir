The golden comparator's aperture: how much a step of its input at time tau still matters to the decision (M4e-kick, #10942)
* specs/analog/decks/sar_kick_aperture.cir -- sar_kick_edge.cir (the golden comparator, SAR_logic and clock_gen with the two gates on ideal sources, the plates' tracking history tp = 14 ns) with ONE thing
* added: the gate of VDP takes a step of dv = 1 mV at the time tau (20 ps ramp), and the decision is read as the difference of the latch's two outputs, v(dp) - v(dn), 4.8 ns after the
* clock edge's 0.1 V crossing (104.107 ns; 5.0 ns after gives the same ratios). The latch amplifies a small difference of its inputs exponentially, so the response is proportional to dv for a
* small step and the ratio of the response to a step at tau to the response to a step before the edge is the share of the decision that the input still decides at tau: 1 until the pair
* begins to lose its gain and 0 once the latch has locked. The kick of the comparator's own plates moves VDP - VDN through that window, and sar_kick_net.t27 weighs it by this aperture.
* The unperturbed run has dp = dn (the plates are alike); the steps at 98.3069 ns (before the edge), at 0.5 mV and at 2 mV, give the same response to 0.1 percent (LINEAR rows).
* Paths are NOT in this file: IHP_PDK, IHP_OSDI and SAR_GOLDEN_SUBCKTS as in sar_kick_edge.cir. Run: ngspice -b sar_kick_aperture.cir   (ngspice-47, about two minutes)
* It prints one row per tau between BEGIN aperture and END aperture: tau - 99.3069 ns (the clkc 0.1 V crossing of the unperturbed run) in ns, and the response in volts.
.param vg=0.742
.param tp=14n
.param tau=1
.param dv=0
.lib $IHP_PDK/ihp-sg13g2/libs.tech/ngspice/models/cornerMOSlv.lib mos_tt
.lib $IHP_PDK/ihp-sg13g2/libs.tech/ngspice/models/cornerCAP.lib cap_typ
.include $SAR_GOLDEN_SUBCKTS
VDD4 vdda 0 1.5
VDD6 vdd 0 1.5
VDD1 vss 0 0
V2 c 0 0
V5 b 0 0
V6 a 0 0
VCLKS clks 0 PULSE(0 1.5 0n 2n 2n 80n 500n)
BPD vdpi 0 V = {vg}*(1-exp(-time/{tp}))+{dv}*min(max((time-{tau})/20p,0),1)
BND vdni 0 V = {vg}*(1-exp(-time/{tp}))
VMP vdpi vdp 0
VMN vdni vdn 0
x3 vocp vocn valid vdp vdn clkc vdd 0 dynamic_comparator_top
x7 ck3 ck11 ck7 ck2 ck6 ck10 ck1 ck9 ck5 ck8 ck4 vdd 0 vdd valid 0 clks SAR_logic
x4 vdd clkc 0 clks valid ck1 a b c clock_gen
C9 clkc 0 4f
C10 vocp 0 4f
C11 valid 0 4f
C12 vocn 0 4f
C13 clkc 0 4f
C14 clks 0 4f
C15 valid 0 4f
C16 ck1 0 4f
C17 a 0 4f
C18 b 0 4f
C19 c 0 4f
C20 clks 0 4f
C21 valid 0 4f
.options temp=50
.options klu
.control
pre_osdi $IHP_OSDI/psp103.osdi
pre_osdi $IHP_OSDI/psp103_nqs.osdi
pre_osdi $IHP_OSDI/r3_cmc.osdi
pre_osdi $IHP_OSDI/mosvar.osdi
pre_osdi $IHP_OSDI/cap_cmomi.osdi
pre_osdi $IHP_OSDI/cap_cmomf.osdi
set num_threads=4
echo BEGIN aperture
foreach tauv 98.3069n 102.3069n 102.4319n 102.5569n 102.6819n 102.8069n 102.9319n 103.0569n 103.1819n 103.3069n 103.4319n 103.5569n 103.6819n 103.8069n 103.9319n 104.0569n 104.1819n
  alterparam vg = 0.742
  alterparam tp = 14n
  alterparam tau = $tauv
  alterparam dv = 0.001
  reset
  tran 0.05n 107n
  meas tran dd find v(x3.dp) at=104.1069n
  meas tran de find v(x3.dn) at=104.1069n
  echo APERTURE $tauv
  print dd de
end
foreach dvv 0 0.0005 0.002
  alterparam vg = 0.742
  alterparam tp = 14n
  alterparam tau = 98.3069n
  alterparam dv = $dvv
  reset
  tran 0.05n 107n
  meas tran dd find v(x3.dp) at=104.1069n
  meas tran de find v(x3.dn) at=104.1069n
  echo LINEAR $dvv
  print dd de
end
echo END aperture
.endc
.end
