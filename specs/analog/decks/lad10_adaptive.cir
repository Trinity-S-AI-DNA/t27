10-node RC ladder (beyond the M1 cell), ngspice default adaptive transient
* specs/analog/decks/lad10_adaptive.cir -- test data for specs/analog/bench.t27 (#10505). A plain netlist, no .control block.
* The same circuit and run as lad10_fixed.cir (not a circuit of specs/analog/linear.t27), written as a user would write
* it: a PWL source and the default options (trapezoidal integration, reltol 1e-3, ngspice's own step control). tmax is
* its default, min(tstep, tstop/50) = 50 ns.
* IN = 1 V until 5000 ns and 0 V from 5050 ns: step 99 of the run ends at 5000 ns, step 100 at 5050 ns, and the source
* carries the value of the step's END point, as the backward Euler recurrence does. uic with IC=0 starts all nodes at 0 V.
* Run: ngspice -b -r lad10_adaptive.raw lad10_adaptive.cir   (the raw file holds float64 values)
V1 in 0 PWL(0 1 5000n 1 5050n 0)
R1 in 1 1k
R2 1 2 1k
R3 2 3 1k
R4 3 4 1k
R5 4 5 1k
R6 5 6 1k
R7 6 7 1k
R8 7 8 1k
R9 8 9 1k
R10 9 10 1k
C1 1 0 1n IC=0
C2 2 0 1n IC=0
C3 3 0 1n IC=0
C4 4 0 1n IC=0
C5 5 0 1n IC=0
C6 6 0 1n IC=0
C7 7 0 1n IC=0
C8 8 0 1n IC=0
C9 9 0 1n IC=0
C10 10 0 1n IC=0
.tran 50n 10000n uic
.end
