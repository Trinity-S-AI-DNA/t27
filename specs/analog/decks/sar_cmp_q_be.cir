SAR ADC dynamic comparator on PSP103 at 27 C with all its charge: backward Euler on a fixed grid of 0.2, 0.4, 0.8 and 1.6 ps, the scheme of sar_comparator_q.t27
* specs/analog/decks/sar_cmp_q_be.cir -- reference data for specs/analog/sar_comparator_q.t27 (analog M4b-q, #11312, epic #10486). The netlist and the settled start of sar_cmp_q_ref.cir (read
* its header: the .ic WITHOUT uic, the DC operating point with the eight nodes forced), integrated by the scheme the model uses: `.options method=gear maxord=1` is backward Euler and trtol 1e7
* stops the truncation test from shrinking a step (the recipe of sar_cmp_psp_r2.cir), the step fixed by tran's tstep and tmax, the clock a B source of nint(time / dt) (no breakpoint: ngspice's
* time points are a few fs before a multiple of dt, and nint puts each on its grid index): 0 at index 0, then a ramp of R steps (R dt = 1.6 ps, the spec's clock) to 1.5 V. Index j of this deck is
* step j of the model. The same inputs as sar_cmp_q_ref.cir. Run: IHP_PDK=<checkout> IHP_OSDI=<osdi dir> ngspice -b sar_cmp_q_be.cir > sar_cmp_q_be.out    (ngspice-47)
* What it prints, per run, after "RUN <dt in fs> <h> <sg>": tck (the clock through 0.75 V), tfirst, tres, dpend, dnend (at 2 ns); the +2 mV run of each dt adds "NODES <dt in fs> <t>": the eight nodes
* ap an net1 net2 net3 dp dn n_clkc at the times of sar_cmp_q_ref.cir. The last block ("RESETRUN", 1.6 ps grid, the clock falling at index 1250, 2 ns) is the reset phase of sar_cmp_q_ref.cir on this grid.
.lib $IHP_PDK/ihp-sg13g2/libs.tech/ngspice/models/cornerMOSlv.lib mos_tt
Vdd vdd 0 1.5
Vdp vdp 0 0.75
Vdn vdn 0 0.75
.param dtp=0.8p
.param rr=2
.param nf=1000000000
Bclk clkc 0 V = 1.5*min(max(nint(time/{dtp}),0),{rr})/{rr}*(1-min(max(nint(time/{dtp})-{nf},0),{rr})/{rr})
XM1 ap clkc vdd vdd sg13_lv_pmos w=3.0u l=0.45u ng=1 m=9
XM2 an clkc vdd vdd sg13_lv_pmos w=3.0u l=0.45u ng=1 m=9
XM3 ap vdn net1 0 sg13_lv_nmos w=1.0u l=0.45u ng=1 m=36
XM4 an vdp net1 0 sg13_lv_nmos w=1.0u l=0.45u ng=1 m=36
XM5 net1 clkc 0 0 sg13_lv_nmos w=1.0u l=0.45u ng=1 m=18
XM6 net2 dp vdd vdd sg13_lv_pmos w=3.0u l=0.45u ng=1 m=30
XM7 net3 dn vdd vdd sg13_lv_pmos w=3.0u l=0.45u ng=1 m=30
XM8 dp an net3 vdd sg13_lv_pmos w=3.0u l=0.45u ng=1 m=30
XM9 dn ap net2 vdd sg13_lv_pmos w=3.0u l=0.45u ng=1 m=30
XM10 dn dp 0 0 sg13_lv_nmos w=1.0u l=0.45u ng=1 m=12
XM11 dp dn 0 0 sg13_lv_nmos w=1.0u l=0.45u ng=1 m=12
XM12 dn n_clkc 0 0 sg13_lv_nmos w=1.0u l=0.45u ng=1 m=6
XM13 dp n_clkc 0 0 sg13_lv_nmos w=1.0u l=0.45u ng=1 m=6
XIP n_clkc clkc vdd vdd sg13_lv_pmos w=3.0u l=0.45u ng=1 m=1
XIN n_clkc clkc 0 0 sg13_lv_nmos w=1.0u l=0.45u ng=1 m=1
Cbdp dp 0 4f
Cbdn dn 0 4f
Bmx mx 0 V = max(v(dp),v(dn))
Bdiff diff 0 V = abs(v(dp)-v(dn))
.ic v(ap)=1.5 v(an)=1.5 v(net1)=0.4009999632835388 v(net2)=1.5 v(net3)=1.5 v(dp)=0 v(dn)=0 v(n_clkc)=1.5
.temp 27
.options method=gear maxord=1 trtol=1e7 reltol=1e-7 vntol=1e-10 abstol=1e-12 gmin=1e-12 itl4=200
.control
set num_threads=2
pre_osdi $IHP_OSDI/psp103.osdi
pre_osdi $IHP_OSDI/psp103_nqs.osdi
set numdgt=10
set noprintscale
alterparam dtp = 0.2p
alterparam rr = 8
reset
foreach h 16777 4194
  foreach sg 1 -1
    alter Vdp = 0.75 + $sg * $h / 16777216
    alter Vdn = 0.75 - $sg * $h / 16777216
    tran 0.2p 2n 0 0.2p
    echo RUN 200 $h $sg
    meas tran tck when v(clkc)=0.75 rise=1
    meas tran tfirst when v(mx)=0.75 rise=1
    meas tran tres when v(diff)=0.75 rise=1
    meas tran dpend find v(dp) at=2n
    meas tran dnend find v(dn) at=2n
  end
end
alter Vdp = 0.75 + 16777 / 16777216
alter Vdn = 0.75 - 16777 / 16777216
tran 0.2p 2.3n 0 0.2p
meas tran tck when v(clkc)=0.75 rise=1
foreach dtn 0p 10p 25p 50p 100p 200p 300p 400p 450p 500p 1000p 1500p 2000p
  let tt = tck + $dtn
  echo NODES 200 $dtn
  meas tran vap find v(ap) at=$&tt
  meas tran van find v(an) at=$&tt
  meas tran vn1 find v(net1) at=$&tt
  meas tran vn2 find v(net2) at=$&tt
  meas tran vn3 find v(net3) at=$&tt
  meas tran vdp find v(dp) at=$&tt
  meas tran vdn find v(dn) at=$&tt
  meas tran vnc find v(n_clkc) at=$&tt
end
alterparam dtp = 0.4p
alterparam rr = 4
reset
foreach h 16777 4194
  foreach sg 1 -1
    alter Vdp = 0.75 + $sg * $h / 16777216
    alter Vdn = 0.75 - $sg * $h / 16777216
    tran 0.4p 2n 0 0.4p
    echo RUN 400 $h $sg
    meas tran tck when v(clkc)=0.75 rise=1
    meas tran tfirst when v(mx)=0.75 rise=1
    meas tran tres when v(diff)=0.75 rise=1
    meas tran dpend find v(dp) at=2n
    meas tran dnend find v(dn) at=2n
  end
end
alter Vdp = 0.75 + 16777 / 16777216
alter Vdn = 0.75 - 16777 / 16777216
tran 0.4p 2.3n 0 0.4p
meas tran tck when v(clkc)=0.75 rise=1
foreach dtn 0p 10p 25p 50p 100p 200p 300p 400p 450p 500p 1000p 1500p 2000p
  let tt = tck + $dtn
  echo NODES 400 $dtn
  meas tran vap find v(ap) at=$&tt
  meas tran van find v(an) at=$&tt
  meas tran vn1 find v(net1) at=$&tt
  meas tran vn2 find v(net2) at=$&tt
  meas tran vn3 find v(net3) at=$&tt
  meas tran vdp find v(dp) at=$&tt
  meas tran vdn find v(dn) at=$&tt
  meas tran vnc find v(n_clkc) at=$&tt
end
alterparam dtp = 0.8p
alterparam rr = 2
reset
foreach h 16777 4194
  foreach sg 1 -1
    alter Vdp = 0.75 + $sg * $h / 16777216
    alter Vdn = 0.75 - $sg * $h / 16777216
    tran 0.8p 2n 0 0.8p
    echo RUN 800 $h $sg
    meas tran tck when v(clkc)=0.75 rise=1
    meas tran tfirst when v(mx)=0.75 rise=1
    meas tran tres when v(diff)=0.75 rise=1
    meas tran dpend find v(dp) at=2n
    meas tran dnend find v(dn) at=2n
  end
end
alter Vdp = 0.75 + 16777 / 16777216
alter Vdn = 0.75 - 16777 / 16777216
tran 0.8p 2.3n 0 0.8p
meas tran tck when v(clkc)=0.75 rise=1
foreach dtn 0p 10p 25p 50p 100p 200p 300p 400p 450p 500p 1000p 1500p 2000p
  let tt = tck + $dtn
  echo NODES 800 $dtn
  meas tran vap find v(ap) at=$&tt
  meas tran van find v(an) at=$&tt
  meas tran vn1 find v(net1) at=$&tt
  meas tran vn2 find v(net2) at=$&tt
  meas tran vn3 find v(net3) at=$&tt
  meas tran vdp find v(dp) at=$&tt
  meas tran vdn find v(dn) at=$&tt
  meas tran vnc find v(n_clkc) at=$&tt
end
alterparam dtp = 1.6p
alterparam rr = 1
reset
foreach h 16777 4194
  foreach sg 1 -1
    alter Vdp = 0.75 + $sg * $h / 16777216
    alter Vdn = 0.75 - $sg * $h / 16777216
    tran 1.6p 2n 0 1.6p
    echo RUN 1600 $h $sg
    meas tran tck when v(clkc)=0.75 rise=1
    meas tran tfirst when v(mx)=0.75 rise=1
    meas tran tres when v(diff)=0.75 rise=1
    meas tran dpend find v(dp) at=2n
    meas tran dnend find v(dn) at=2n
  end
end
alter Vdp = 0.75 + 16777 / 16777216
alter Vdn = 0.75 - 16777 / 16777216
tran 1.6p 2.3n 0 1.6p
meas tran tck when v(clkc)=0.75 rise=1
foreach dtn 0p 10p 25p 50p 100p 200p 300p 400p 450p 500p 1000p 1500p 2000p
  let tt = tck + $dtn
  echo NODES 1600 $dtn
  meas tran vap find v(ap) at=$&tt
  meas tran van find v(an) at=$&tt
  meas tran vn1 find v(net1) at=$&tt
  meas tran vn2 find v(net2) at=$&tt
  meas tran vn3 find v(net3) at=$&tt
  meas tran vdp find v(dp) at=$&tt
  meas tran vdn find v(dn) at=$&tt
  meas tran vnc find v(n_clkc) at=$&tt
end
alterparam dtp = 1.6p
alterparam rr = 1
alterparam nf = 1250
reset
alter Vdp = 0.75 + 16777 / 16777216
alter Vdn = 0.75 - 16777 / 16777216
tran 1.6p 3.5n 0 1.6p
echo RESETRUN
foreach dtn 1900p 2000p 2050p 2100p 2200p 2400p 2800p 3400p
  let tt = $dtn
  echo RESET $dtn
  meas tran vap find v(ap) at=$&tt
  meas tran van find v(an) at=$&tt
  meas tran vn1 find v(net1) at=$&tt
  meas tran vn2 find v(net2) at=$&tt
  meas tran vn3 find v(net3) at=$&tt
  meas tran vdp find v(dp) at=$&tt
  meas tran vdn find v(dn) at=$&tt
  meas tran vnc find v(n_clkc) at=$&tt
end
.endc
.end
