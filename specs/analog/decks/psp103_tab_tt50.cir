IHP SG13G2 PSP103 tables, corner mos_tt, 50 C
* specs/analog/decks/psp103_tab_tt50.cir -- table data for specs/analog/mos_psp103_50c_data.t27 (analog M4b-psp, #10856, epic #10486). A netlist plus a
* .control block that prints the numbers: psp103_tab_tt.cir (M3b, #10516) at the temperature of the golden SAR deck, nothing else changed. The
* golden deck says `.options TEMP = 50` (the converter's own run is at 50 C); M3b tabulated 27 C. The IHP corner file is read at run time and never
* copied here. Model: IHP-Open-PDK commit 21133f219b1a6da10d803e345761e77415ceff40, ihp-sg13g2/libs.tech/ngspice/models/cornerMOSlv.lib (PSP 103.6,
* revision 200310), section mos_tt; the model code is libs.tech/verilog-a/psp103/psp103.va of the same commit, compiled with OpenVAF-Reloaded
* v24.0.2mob to psp103.osdi (and psp103_nqs.osdi). TNOM is 27 C and the circuit temperature 50 C: `.temp 50`. Devices: sg13_lv_nmos w=1.0u l=0.45u
* ng=1 m=1 and sg13_lv_pmos w=3.0u l=0.45u ng=1 m=1. Solver options as in psp103_tab_tt.cir: reltol 1e-6, vntol 1e-9, abstol 1e-14.
* Paths are NOT in this file. ngspice reads two environment variables: IHP_PDK, the IHP-Open-PDK checkout, and IHP_OSDI, the directory that
* holds the compiled psp103.osdi and psp103_nqs.osdi.
* Run: IHP_PDK=<checkout> IHP_OSDI=<osdi dir> ngspice -b psp103_tab_tt50.cir > psp103_tab_tt50.out    (ngspice-47)
* What it prints. Between "BEGIN name" and "END name" every row "<index> TAB <value>" is one number, in sweep order (the first sweep source runs
* fastest). The values are pasted into the spec in that order, none changed.
*   grid_n  Id of the nmos at Vgs = ix * 62.5 mV, Vds = iy * 62.5 mV, ix and iy 0..24, 625 rows, ix outer, in table units: nint(Id * 200 V/A *
*           2^24 units/V), the current times dt/C (200 V/A) in units of 2^-24 V, one unit 0.298 nA. Negative values (the gate current that leaves
*           through the drain at Vds = 0) are held at 0: the table is unsigned.
*   grid_p  the same for the pmos at Vsg = ix * 62.5 mV, Vsd = iy * 62.5 mV (source and bulk on the 1.5 V rail; the current that leaves the drain).
*   r2_n, r2_p  Id in pA (nint(Id * 1e12)) at the first 200 held-out points of the R2 low-discrepancy sequence: point k is Vgs (Vsg) = 1.5 frac(k a1),
*           Vds (Vsd) = 1.5 frac(k a2), a1 = 0.7548776662466927, a2 = 0.5698402909980532, k = 1..200: held-out points, never on a table node.
* nmos table device: drain VDN, gate VGN, source and bulk at 0 V
.lib $IHP_PDK/ihp-sg13g2/libs.tech/ngspice/models/cornerMOSlv.lib mos_tt
VDN dn 0 0
VGN gn 0 0
XMN dn gn 0 0 sg13_lv_nmos w=1.0u l=0.45u ng=1 m=1
* pmos table device: source and bulk at the 1.5 V rail, drain VDP and gate VGP, both swept downward from 1.5 V
VSP sp 0 1.5
VDP dp 0 1.5
VGP gp 0 1.5
XMP dp gp sp sp sg13_lv_pmos w=3.0u l=0.45u ng=1 m=1
* held-out points: B sources compute the R2 point from the sweep variable k; the zero-volt sources VRDN, VRDP measure the drain current
VK k 0 1
BRGN rgn 0 V = 1.5*(v(k)*0.7548776662466927-floor(v(k)*0.7548776662466927))
BRDN rdn0 0 V = 1.5*(v(k)*0.5698402909980532-floor(v(k)*0.5698402909980532))
VRDN rdn0 rdn 0
XRN rdn rgn 0 0 sg13_lv_nmos w=1.0u l=0.45u ng=1 m=1
BRGP rgp 0 V = 1.5-1.5*(v(k)*0.7548776662466927-floor(v(k)*0.7548776662466927))
BRDP rdp0 0 V = 1.5-1.5*(v(k)*0.5698402909980532-floor(v(k)*0.5698402909980532))
VRDP rdp rdp0 0
VRSP rsp 0 1.5
XRP rdp rgp rsp rsp sg13_lv_pmos w=3.0u l=0.45u ng=1 m=1
.temp 50
.options reltol=1e-6 vntol=1e-9 abstol=1e-14
.control
pre_osdi $IHP_OSDI/psp103.osdi
pre_osdi $IHP_OSDI/psp103_nqs.osdi
set numdgt=10
set noprintscale
echo BEGIN grid_n
dc VDN 0 1.5 0.0625 VGN 0 1.5 0.0625
let u = nint(-i(VDN) * 200 * 16777216)
let u = (u + abs(u)) / 2
print u
echo END grid_n
echo BEGIN grid_p
dc VDP 1.5 0 -0.0625 VGP 1.5 0 -0.0625
let u = nint(i(VDP) * 200 * 16777216)
let u = (u + abs(u)) / 2
print u
echo END grid_p
echo BEGIN r2_n
dc VK 1 200 1
let u = nint(i(VRDN) * 1e12)
print u
echo END r2_n
echo BEGIN r2_p
let u = nint(i(VRDP) * 1e12)
print u
echo END r2_p
.endc
.end
