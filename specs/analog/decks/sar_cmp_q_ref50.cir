SAR ADC dynamic comparator on PSP103 at 50 C with all its charge and the golden bulks: the proof that sar_cmp_q_ref.cir is the golden comparator
* specs/analog/decks/sar_cmp_q_ref50.cir -- the check of specs/analog/decks/sar_cmp_q_ref.cir (analog M4b-q, #11312, epic #10486), read its header: the same netlist (the thirteen
* sg13_lv transistors of the golden dynamic_comparator and its inverter, W, L and m of sar_cmp_psp_r2b.cir, the bulks as the golden deck has them, 4 fF on dp and dn, an ideal 1.6 ps clock)
* at 50 C, the golden deck's temperature. "RUN U" is the start of sar_cmp_psp_real.cir (uic, the clock at 200 ps), which, read from the file named by SAR_GOLDEN_SUBCKTS, measured the first output
* through 0.75 V at 523.032 ps (h = 16777), 528.007, 529.386 and 529.741 ps (h = 4194, 1049, 262) after the clock's 50 % point (NG_RL_FIRST_PS of sar_comparator_psp.t27): this written-out
* netlist is that circuit if it prints the same times. No golden file is read. "RUN S" is the settled start of sar_cmp_q_ref.cir, at 50 C, for the comparison of the two starts.
* Run: IHP_PDK=<checkout> IHP_OSDI=<osdi dir> ngspice -b sar_cmp_q_ref50.cir > sar_cmp_q_ref50.out    (ngspice-47)
.lib $IHP_PDK/ihp-sg13g2/libs.tech/ngspice/models/cornerMOSlv.lib mos_tt
Vdd vdd 0 1.5
Vdp vdp 0 0.75
Vdn vdn 0 0.75
.param tclk=200p
.param tfall=1
Bclk clkc 0 V = 1.5*min(max((time-{tclk})/1.6p,0),1)*(1-min(max((time-{tfall})/1.6p,0),1))
XM1 ap clkc vdd vdd sg13_lv_pmos w=3.0u l=0.45u ng=1 m=9
XM2 an clkc vdd vdd sg13_lv_pmos w=3.0u l=0.45u ng=1 m=9
XM3 ap vdn net1 0 sg13_lv_nmos w=1.0u l=0.45u ng=1 m=36
XM4 an vdp net1 0 sg13_lv_nmos w=1.0u l=0.45u ng=1 m=36
XM5 net1 clkc 0 0 sg13_lv_nmos w=1.0u l=0.45u ng=1 m=18
XM6 net2 dp vdd vdd sg13_lv_pmos w=3.0u l=0.45u ng=1 m=30
XM7 net3 dn vdd vdd sg13_lv_pmos w=3.0u l=0.45u ng=1 m=30
XM8 dp an net3 vdd sg13_lv_pmos w=3.0u l=0.45u ng=1 m=30
XM9 dn ap net2 vdd sg13_lv_pmos w=3.0u l=0.45u ng=1 m=30
XM10 dn dp 0 0 sg13_lv_nmos w=1.0u l=0.45u ng=1 m=12
XM11 dp dn 0 0 sg13_lv_nmos w=1.0u l=0.45u ng=1 m=12
XM12 dn n_clkc 0 0 sg13_lv_nmos w=1.0u l=0.45u ng=1 m=6
XM13 dp n_clkc 0 0 sg13_lv_nmos w=1.0u l=0.45u ng=1 m=6
XIP n_clkc clkc vdd vdd sg13_lv_pmos w=3.0u l=0.45u ng=1 m=1
XIN n_clkc clkc 0 0 sg13_lv_nmos w=1.0u l=0.45u ng=1 m=1
Cbdp dp 0 4f
Cbdn dn 0 4f
Bmx mx 0 V = max(v(dp),v(dn))
Bdiff diff 0 V = abs(v(dp)-v(dn))
.ic v(ap)=1.5 v(an)=1.5 v(net1)=0.4009999632835388 v(net2)=1.5 v(net3)=1.5 v(dp)=0 v(dn)=0 v(n_clkc)=1.5
.temp 50
.options reltol=1e-8 vntol=1e-11 abstol=1e-13 itl4=200
.control
set num_threads=2
pre_osdi $IHP_OSDI/psp103.osdi
pre_osdi $IHP_OSDI/psp103_nqs.osdi
set numdgt=10
set noprintscale
alterparam tclk = 200p
reset
foreach h 16777 4194 1049 262
  foreach sg 1 -1
    alter Vdp = 0.75 + $sg * $h / 16777216
    alter Vdn = 0.75 - $sg * $h / 16777216
    tran 0.1p 3n 0 0.5p uic
    echo RUN U $h $sg
    meas tran tck when v(clkc)=0.75 rise=1
    meas tran tfirst when v(mx)=0.75 rise=1
    meas tran tres when v(diff)=0.75 rise=1
    meas tran dpend find v(dp) at=3n
    meas tran dnend find v(dn) at=3n
  end
end
alterparam tclk = 1p
reset
foreach h 16777 4194
  foreach sg 1 -1
    alter Vdp = 0.75 + $sg * $h / 16777216
    alter Vdn = 0.75 - $sg * $h / 16777216
    tran 0.1p 3n 0 0.5p
    echo RUN S $h $sg
    meas tran tck when v(clkc)=0.75 rise=1
    meas tran tfirst when v(mx)=0.75 rise=1
    meas tran tres when v(diff)=0.75 rise=1
    meas tran dpend find v(dp) at=3n
    meas tran dnend find v(dn) at=3n
  end
end
.endc
.end
