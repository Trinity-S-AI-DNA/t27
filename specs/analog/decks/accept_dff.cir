IHP SG13G2 dff of the golden SAR deck at transistor level, PSP103 mos_tt 27 C: Q and nQ after reset, capture 1, capture 0 and set
* specs/analog/decks/accept_dff.cir -- reference data for the dff's levels row of specs/analog/accept_sar.t27 (M5g, #11400, epic #10486).
* The dff is the golden SAR deck's own subcircuit (the file top.spice of its parser's golden directory, GPL-2.0: fetched at run time, never vendored), included from
* SAR_GOLDEN_SUBCKTS (made at run time: sed -n '/^.subckt tracking_switch/,$p' top.spice | grep -v -i -E '^\.(end|global)([[:space:]]|$)').
* Pins of the golden subcircuit: dff VDD VSS Q CLK nQ D Reset Set. No load on Q or nQ: the level is the DC level the cell settles to.
* Stimulus (edges 0.2 ns): Reset high to 10 ns; CLK rises at 20 ns and 50 ns (high 10 ns each); D is 1.5 V to 40 ns, then 0;
* Set high from 70 ns to 80 ns. Measured after each state has settled: reset (15 ns), capture 1 (45 ns), capture 0 (68 ns), set (95 ns).
* Prints dev_<node>_<state>, the deviation from the rail in volts, 6 significant digits: for a 1 the voltage from VDD to the node (dq, dnq below),
* for a 0 the node itself, so the digits fall on the deviation and not on the 1.5 V.
* Paths are NOT in this file: ngspice reads IHP_PDK, IHP_OSDI and SAR_GOLDEN_SUBCKTS from the environment.
* Run: IHP_PDK=<checkout> IHP_OSDI=<osdi dir> SAR_GOLDEN_SUBCKTS=<file> ngspice -b accept_dff.cir   (ngspice-47)
.lib $IHP_PDK/ihp-sg13g2/libs.tech/ngspice/models/cornerMOSlv.lib mos_tt
.include $SAR_GOLDEN_SUBCKTS
.temp 27
.options reltol=1e-7 vntol=1e-12 abstol=1e-15 gmin=1e-15 itl1=500 itl4=200 num_threads=2
VDD vdd 0 1.5
VSS vss 0 0
VRST rst 0 PWL(0 1.5 10n 1.5 10.2n 0)
VSET set 0 PWL(0 0 70n 0 70.2n 1.5 80n 1.5 80.2n 0)
VD d 0 PWL(0 1.5 40n 1.5 40.2n 0)
VCLK clk 0 PWL(0 0 20n 0 20.2n 1.5 30n 1.5 30.2n 0 50n 0 50.2n 1.5 60n 1.5 60.2n 0)
XD vdd vss q clk nq d rst set dff
* ideal voltage-controlled sources (no load on the cell): dq = VDD - Q, dnq = VDD - nQ, the deviation of a 1 level
EDQ dq 0 vdd q 1
EDNQ dnq 0 vdd nq 1
.tran 5p 100n
.control
pre_osdi $IHP_OSDI/psp103.osdi
pre_osdi $IHP_OSDI/psp103_nqs.osdi
set numdgt=12
run
meas tran dev_q_rst FIND v(q) AT=15n
meas tran dev_nq_rst FIND v(dnq) AT=15n
meas tran dev_q_c1 FIND v(dq) AT=45n
meas tran dev_nq_c1 FIND v(nq) AT=45n
meas tran dev_q_c0 FIND v(q) AT=68n
meas tran dev_nq_c0 FIND v(dnq) AT=68n
meas tran dev_q_set FIND v(dq) AT=95n
meas tran dev_nq_set FIND v(nq) AT=95n
.endc
.end
