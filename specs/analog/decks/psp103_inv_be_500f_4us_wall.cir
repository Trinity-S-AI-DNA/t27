IHP SG13G2 inverter, 500 fF, backward Euler on a fixed 100 ps grid, corner mos_tt
* specs/analog/decks/psp103_inv_be_500f_4us_wall.cir -- the wall-time deck of specs/analog/bench.t27 (#11291, epic #10486). It is
* specs/analog/decks/psp103_inv_be_500f.cir with three changes to the netlist and the control block, and one removal; the circuit, the
* models, the options and the source are the same lines:
*   1. .tran stop 4.0004u instead of 40.4n: 40004 steps of 100 ps instead of 404, so that ngspice's "Transient analysis time" is most
*      of its process time (at 40.4 ns the process is mostly start-up and the .tran is about a tenth of it);
*   2. "set num_threads=1" before "run": one host thread, so the time is one core's;
*   3. "rusage all" after "run": ngspice prints its own time and memory use, among them "Transient analysis time", "Transient
*      timepoints" and "Total elapsed time", which are the numbers bench.t27 stores.
*   Removed: the print block of M3c (set numdgt .. print ts ys .. echo END tran_be). It is the waveform of the 40.4 ns run; the run that
*   was timed did not print it, and this deck is the run that was timed.
* The 40 ns row of bench.t27 is this deck with the stop 40.4n (the committed deck with changes 2 and 3 and without its print block).
* Paths are NOT in this file: ngspice reads IHP_PDK and IHP_OSDI from the environment (see psp103_tab_tt.cir).
* Run: IHP_PDK=<checkout> IHP_OSDI=<osdi dir> ngspice -b psp103_inv_be_500f_4us_wall.cir    (ngspice-47)
* The batch log holds two runs of the .tran. The rusage lines are printed right after the first, the control block's "run", and are the
* ones bench.t27 stores; the summary at exit is cumulative over both runs.
* Grid: tstep = 0.78125 dt makes the opening ramp end exactly at dt = 100 ps, so every internal point from then on is a multiple of dt. The
* input is a B source of nint(time / dt): Vdd up to index 1, 0 V from index 2 (150 ps) to index 201, Vdd from index 202. Step k of the spec ends
* at (k + 2) dt; step 0 starts at t = dt = 100 ps and step 200 at 201 dt = 20.1 ns.
* What it prints (ngspice .meas, 6 digits, in s): tplh and tphl, the times at which the output crosses 0.75 V rising (after step 0's edge) and
* falling (after step 200's edge); the delays are these minus 100 ps and minus 20.1 ns. The logs of the 4 us run and the 40.4 ns run print
* the same two numbers: both see the same two edges, and the input has no later one.
.lib $IHP_PDK/ihp-sg13g2/libs.tech/ngspice/models/cornerMOSlv.lib mos_tt
VDD vdd 0 1.5
Bin in 0 V = 1.5*(1-min(max(nint(time/1e-10)-1,0),1)+min(max(nint(time/1e-10)-201,0),1))
XIP out in vdd vdd sg13_lv_pmos w=3.0u l=0.45u ng=1 m=1
XIN out in 0 0 sg13_lv_nmos w=1.0u l=0.45u ng=1 m=1
CL out 0 500f
.temp 27
.options method=gear maxord=1 trtol=1e7 reltol=1e-6 vntol=1e-9 abstol=1e-12 itl4=200
.tran 78.125p 4.0004u 0 100p
.meas tran tplh when v(out)=0.75 rise=1
.meas tran tphl when v(out)=0.75 fall=1
.control
pre_osdi $IHP_OSDI/psp103.osdi
pre_osdi $IHP_OSDI/psp103_nqs.osdi
set num_threads=1
run
rusage all
.endc
.end
