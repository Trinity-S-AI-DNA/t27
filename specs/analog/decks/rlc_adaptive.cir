M1 series RLC, ngspice default adaptive transient
* specs/analog/decks/rlc_adaptive.cir -- test data for specs/analog/bench.t27 (#10505). A plain netlist, no .control block.
* The same circuit and run as rlc_fixed.cir, written as a user would write it: a PWL source and the default options
* (trapezoidal integration, reltol 1e-3, ngspice's own step control). tmax is its default, min(tstep, tstop/50) = 5 ns.
* IN = 1 V until 500 ns and 0 V from 505 ns: step 99 of the run ends at 500 ns, step 100 at 505 ns, and the source
* carries the value of the step's END point, as the backward Euler recurrence does. uic with IC=0 starts the capacitor
* voltage and the inductor current at 0.
* Run: ngspice -b -r rlc_adaptive.raw rlc_adaptive.cir   (the raw file holds float64 values)
V1 in 0 PWL(0 1 500n 1 505n 0)
R1 in 1 100
L1 1 2 10u IC=0
C1 2 0 1n IC=0
.tran 5n 1000n uic
.end
