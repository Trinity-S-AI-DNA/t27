The comparator's aperture at a late decision of the golden SAR ADC's sine run: how much a step of its input at time tau still matters to the decision, with the plates as the DAC left them (M4e-kick, #10942)
* specs/analog/decks/sar_kick_late_aperture.cir -- sar_kick_late.cir (the golden SAR ADC deck, wp2-parser/golden/top.spice, GPL-2.0: fetched at run time, never vendored; the
* subcircuits come from the run-time file SAR_GOLDEN_SUBCKTS, made as in sar_off_base.cir) with ONE thing added: a voltage source BSTEP (and BSTEPN on the gate of VDN, 0 V except in CMODE) in series between the plate VDP and the gate of the
* comparator's input pair, 0 V except for a step of dv = 1 mV at the time tau (20 ps ramp). The plate still feeds the gate its charge (the source carries the gate current), so the plates
* and the comparator's edge are the circuit's own; only the gate sees the step. The decision is read as the latch's two outputs v(x3.dp) - v(x3.dn) 4.8 ns after the clock edge's 0.1 V
* crossing, and the ratio of the response to a step at tau to the response to a step before the edge (tau = the crossing minus 1 ns) is the share of the decision that the input still
* decides at tau: 1 until the pair begins to lose its gain, 0 once the latch has locked. sar_kick_aperture.cir is the same experiment at the first decision with the gates on ideal sources;
* this is it at a late one, whose net1 is 38 to 46 mV lower at the edge (sar_kick_late.cir) and whose latch starts a different state (sar_kick_net.t27 weighs the plates' kick by it).
* The sine run's decisions are deterministic, so the run reproduces sar_kick_late.cir to the step: the unperturbed run (dv 0, the first LINEAR row) has the same 0.1 V crossing, tcb. The
* variable sar_which picks the decision, the way sar_off_base.cir picks its input: 0 is the first conversion's tenth decision (clkc rise 10, tcb = 405.4033 ns, nine plates moved), 1 the
* second conversion's (clkc rise 21, tcb = 912.8183 ns), 2 the first conversion's eleventh decision (rise 11, tcb = 439.1437 ns, ten plates moved), 3 the second's (rise 22, tcb = 947.9562
* ns). sar_part picks the rows: 0 all of LINEAR and APERTURE, 1 LINEAR only, 2 APERTURE only, 3 CMODE only. CMODE steps BOTH gates together (BSTEPN as well as BSTEP, by dv = 2 mV and 4 mV
* before the edge): the response of the margin to the common mode of the two plates, which a step of one gate mixes with the differential one. (The LINEAR rows of which 2 and 3 pinned in
* sar_kick_net.t27 were printed before BSTEPN was added; with it the unperturbed margin of which 2 is 2.55 against 2.52 mV and the balance read from the rows 6.992 against 6.991 mV: the latch
* amplifies the circuit's last rounding.)
* Paths are NOT in this file: IHP_PDK (the IHP-Open-PDK checkout, commit 21133f21), IHP_OSDI (the directory with the compiled psp103.osdi, psp103_nqs.osdi, r3_cmc.osdi, mosvar.osdi,
* cap_cmomi.osdi, cap_cmomf.osdi) and SAR_GOLDEN_SUBCKTS, and sar_which, sar_part, in the environment. Run: sar_which=0 sar_part=0 IHP_PDK=<checkout> IHP_OSDI=<osdi dir>
* SAR_GOLDEN_SUBCKTS=<file> ngspice -b sar_kick_late_aperture.cir (ngspice-47; 20 transients of 0.41 us (which 0), 0.92 us (which 1), 0.44 us (which 2) or 0.95 us (which 3) at 50 ps:
* minutes each on two cores). It prints, between BEGIN aperture and END aperture, the rows LINEAR dv (the step at the crossing minus 1 ns, dv = 0, 0.5 mV and 2 mV), then APERTURE tau (the step
* at the crossing minus 1 ns, then at 3.0 ns + 0.125 ns j after it, dv = 1 mV), then CMODE dv, with dd = v(x3.dp) and de = v(x3.dn) at the read instant, in volts.
.param dmv=0
.param amp=0.6
.param tau=1
.param dv=0
.param dvn=0
.lib $IHP_PDK/ihp-sg13g2/libs.tech/ngspice/models/cornerMOSlv.lib mos_tt
.lib $IHP_PDK/ihp-sg13g2/libs.tech/ngspice/models/cornerCAP.lib cap_typ
.include $SAR_GOLDEN_SUBCKTS
* supplies, trim code A B C = 0 0 0, the common mode, the sampling clock and the differential sine input
VDD4 vdda 0 1.5
VDD6 vdd 0 1.5
VDD7 vcm 0 0.75
V2 c 0 0
V5 b 0 0
V6 a 0 0
VDD1 vss 0 0
VCMS net2 0 0.75
VCLKS clks 0 PULSE(0 1.5 0n 2n 2n 80n 500n)
VSP net2 vinp sin({-dmv*0.5e-3} {amp} 62.5k)
VSN vinn net2 sin({-dmv*0.5e-3} {amp} 62.5k)
* the two tracking switches, the comparator, the SAR logic and the clock generator
x1 vdda 0 vinn vdn clks tracking_switch
x2 vdda 0 vinp vdp clks tracking_switch
x3 vocp vocn valid vdpc vdnc clkc vdd 0 dynamic_comparator_top
* the one addition: the step of the aperture experiment, in series between the plate and the comparator's gate
BSTEP vdpc vdp V = {dv}*min(max((time-{tau})/20p,0),1)
BSTEPN vdnc vdn V = {dvn}*min(max((time-{tau})/20p,0),1)
x7 ck3 ck11 ck7 ck2 ck6 ck10 ck1 ck9 ck5 ck8 ck4 vdd 0 vdd valid 0 clks SAR_logic
x4 vdd clkc 0 clks valid ck1 a b c clock_gen
* the 4 fF loads the golden top hangs on the top plates and on the control nets
C3 vdp 0 4f
C4 vdn 0 4f
C5 vdp 0 4f
C6 vdn 0 4f
C7 vinp 0 4f
C8 vinn 0 4f
C9 clkc 0 4f
C10 vocp 0 4f
C11 valid 0 4f
C12 vocn 0 4f
C13 clkc 0 4f
C14 clks 0 4f
C15 valid 0 4f
C16 ck1 0 4f
C17 a 0 4f
C18 b 0 4f
C19 c 0 4f
C20 clks 0 4f
C21 valid 0 4f
C22 vdd 0 4f
* the bottom-plate drivers (every stage decides on vocn), then the negated copy of each bit for the N half
x5 vdd bit_10 vocn 0 ck11 vcm out_11 0 0 clks bit_9 vocn ck10 out_10 bit_8 vocn ck9 out_9 bit_7 vocn ck8 out_8 bit_6 vocn
+ ck7 out_7 bit_5 vocn ck6 out_6 bit_4 vocn ck5 out_5 bit_3 vocn ck4 out_4 bit_2 vocn ck3 out_3 bit_1 vocn ck2 out_2 bit_0 vocn ck1
+ out_1 DAC_control_top
x6 vdd vss ck11 bit_10 bit_10_n neg_bottom_plate_logic
x8 vdd vss ck6 bit_5 bit_5_n neg_bottom_plate_logic
x9 vdd vss ck10 bit_9 bit_9_n neg_bottom_plate_logic
x10 vdd vss ck5 bit_4 bit_4_n neg_bottom_plate_logic
x11 vdd vss ck9 bit_8 bit_8_n neg_bottom_plate_logic
x12 vdd vss ck4 bit_3 bit_3_n neg_bottom_plate_logic
x13 vdd vss ck8 bit_7 bit_7_n neg_bottom_plate_logic
x14 vdd vss ck3 bit_2 bit_2_n neg_bottom_plate_logic
x15 vdd vss ck7 bit_6 bit_6_n neg_bottom_plate_logic
x16 vdd vss ck2 bit_1 bit_1_n neg_bottom_plate_logic
* the deck's own output adder: V(out) = 1.5 V code / 2048 with the bits at 0 / 1.5 V
E1 out net12 out_11 0 0.5
E2 net12 net11 out_10 0 0.25
E3 net11 net10 out_9 0 0.125
E4 net10 net9 out_8 0 0.0625
E5 net9 net8 out_7 0 0.03125
E6 net8 net7 out_6 0 0.015625
E7 net7 net6 out_5 0 0.0078125
E8 net6 net5 out_4 0 0.00390625
E9 net5 net4 out_3 0 0.001953125
E10 net4 net3 out_2 0 0.0009765625
E11 net3 0 out_1 0 0.00048828125
* the two capacitive DAC halves: the N half on VDN with the negated bits, the P half on VDP
x17 vdn bit_3_n bit_8_n bit_5_n bit_6_n bit_7_n bit_4_n bit_9_n bit_10_n bit_2_n bit_1_n Diff_cap_DAC
x18 vdp bit_3 bit_8 bit_5 bit_6 bit_7 bit_4 bit_9 bit_10 bit_2 bit_1 Diff_cap_DAC
.ic v(x1.net1)=0
.ic v(x1.net2)=0
.nodeset v(x1.net2)=0
.ic v(x1.net3)=0
.ic v(x2.net1)=0
.ic v(x2.net2)=0
.ic v(x2.net3)=0
.ic v(x17.net1)=0
.ic v(x18.net1)=0
.ic v(vdp)=0
.ic v(vdn)=0
.options temp=50
.options klu
.save v(vdp) v(vdn) v(clkc) v(x3.dp) v(x3.dn)
.control
pre_osdi $IHP_OSDI/psp103.osdi
pre_osdi $IHP_OSDI/psp103_nqs.osdi
pre_osdi $IHP_OSDI/r3_cmc.osdi
pre_osdi $IHP_OSDI/mosvar.osdi
pre_osdi $IHP_OSDI/cap_cmomi.osdi
pre_osdi $IHP_OSDI/cap_cmomf.osdi
set num_threads=2
set numdgt=8
set noprintscale
echo BEGIN aperture
if $sar_which = 0
  if $sar_part < 2
    foreach dvv 0 0.0005 0.002
      alterparam tau = 404.4033n
      alterparam dv = $dvv
      alterparam dvn = 0
      reset
      tran 0.05n 410.5n
      meas tran dd find v(x3.dp) at=410.2033n
      meas tran de find v(x3.dn) at=410.2033n
      meas tran tcb when v(clkc)=0.1 rise=10
      echo LINEAR $dvv
      print dd de tcb
    end
  end
  if $sar_part <> 1
    if $sar_part <> 3
      foreach tauv 404.4033n 408.4033n 408.5283n 408.6533n 408.7783n 408.9033n 409.0283n 409.1533n 409.2783n 409.4033n 409.5283n 409.6533n 409.7783n 409.9033n 410.0283n 410.1533n 410.2783n
        alterparam tau = $tauv
        alterparam dv = 0.001
        alterparam dvn = 0
        reset
        tran 0.05n 410.5n
        meas tran dd find v(x3.dp) at=410.2033n
        meas tran de find v(x3.dn) at=410.2033n
        echo APERTURE $tauv
        print dd de
      end
    end
  end
  if $sar_part = 3
    foreach dvv 0.002 0.004
      alterparam tau = 404.4033n
      alterparam dv = $dvv
      alterparam dvn = $dvv
      reset
      tran 0.05n 410.5n
      meas tran dd find v(x3.dp) at=410.2033n
      meas tran de find v(x3.dn) at=410.2033n
      echo CMODE $dvv
      print dd de
    end
  end
else
  if $sar_which = 1
    if $sar_part < 2
      foreach dvv 0 0.0005 0.002
        alterparam tau = 911.8183n
        alterparam dv = $dvv
        alterparam dvn = 0
        reset
        tran 0.05n 917.9n
        meas tran dd find v(x3.dp) at=917.6183n
        meas tran de find v(x3.dn) at=917.6183n
        meas tran tcb when v(clkc)=0.1 rise=21
        echo LINEAR $dvv
        print dd de tcb
      end
    end
    if $sar_part <> 1
      if $sar_part <> 3
        foreach tauv 911.8183n 915.8183n 915.9433n 916.0683n 916.1933n 916.3183n 916.4433n 916.5683n 916.6933n 916.8183n 916.9433n 917.0683n 917.1933n 917.3183n 917.4433n 917.5683n 917.6933n
          alterparam tau = $tauv
          alterparam dv = 0.001
          alterparam dvn = 0
          reset
          tran 0.05n 917.9n
          meas tran dd find v(x3.dp) at=917.6183n
          meas tran de find v(x3.dn) at=917.6183n
          echo APERTURE $tauv
          print dd de
        end
      end
    end
    if $sar_part = 3
      foreach dvv 0.002 0.004
        alterparam tau = 911.8183n
        alterparam dv = $dvv
        alterparam dvn = $dvv
        reset
        tran 0.05n 917.9n
        meas tran dd find v(x3.dp) at=917.6183n
        meas tran de find v(x3.dn) at=917.6183n
        echo CMODE $dvv
        print dd de
      end
    end
  else
    if $sar_which = 2
      if $sar_part < 2
        foreach dvv 0 0.0005 0.002
          alterparam tau = 438.1437n
          alterparam dv = $dvv
          alterparam dvn = 0
          reset
          tran 0.05n 444.5n
          meas tran dd find v(x3.dp) at=443.9437n
          meas tran de find v(x3.dn) at=443.9437n
          meas tran tcb when v(clkc)=0.1 rise=11
          echo LINEAR $dvv
          print dd de tcb
        end
      end
      if $sar_part <> 1
        if $sar_part <> 3
          foreach tauv 438.1437n 442.1437n 442.2687n 442.3937n 442.5187n 442.6437n 442.7687n 442.8937n 443.0187n 443.1437n 443.2687n 443.3937n 443.5187n 443.6437n 443.7687n 443.8937n 444.0187n
            alterparam tau = $tauv
            alterparam dv = 0.001
            alterparam dvn = 0
            reset
            tran 0.05n 444.5n
            meas tran dd find v(x3.dp) at=443.9437n
            meas tran de find v(x3.dn) at=443.9437n
            echo APERTURE $tauv
            print dd de
          end
        end
      end
      if $sar_part = 3
        foreach dvv 0.002 0.004
          alterparam tau = 438.1437n
          alterparam dv = $dvv
          alterparam dvn = $dvv
          reset
          tran 0.05n 444.5n
          meas tran dd find v(x3.dp) at=443.9437n
          meas tran de find v(x3.dn) at=443.9437n
          echo CMODE $dvv
          print dd de
        end
      end
    else
      if $sar_which = 3
        if $sar_part < 2
          foreach dvv 0 0.0005 0.002
            alterparam tau = 946.9562n
            alterparam dv = $dvv
            alterparam dvn = 0
            reset
            tran 0.05n 953n
            meas tran dd find v(x3.dp) at=952.7562n
            meas tran de find v(x3.dn) at=952.7562n
            meas tran tcb when v(clkc)=0.1 rise=22
            echo LINEAR $dvv
            print dd de tcb
          end
        end
        if $sar_part <> 1
          if $sar_part <> 3
            foreach tauv 946.9562n 950.9562n 951.0812n 951.2062n 951.3312n 951.4562n 951.5812n 951.7062n 951.8312n 951.9562n 952.0812n 952.2062n 952.3312n 952.4562n 952.5812n 952.7062n 952.8312n
              alterparam tau = $tauv
              alterparam dv = 0.001
              alterparam dvn = 0
              reset
              tran 0.05n 953n
              meas tran dd find v(x3.dp) at=952.7562n
              meas tran de find v(x3.dn) at=952.7562n
              echo APERTURE $tauv
              print dd de
            end
          end
        end
        if $sar_part = 3
          foreach dvv 0.002 0.004
            alterparam tau = 946.9562n
            alterparam dv = $dvv
            alterparam dvn = $dvv
            reset
            tran 0.05n 953n
            meas tran dd find v(x3.dp) at=952.7562n
            meas tran de find v(x3.dn) at=952.7562n
            echo CMODE $dvv
            print dd de
          end
        end
      end
    end
  end
end
echo END aperture
.endc
.end
