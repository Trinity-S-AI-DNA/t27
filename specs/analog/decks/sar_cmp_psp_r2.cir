SAR ADC dynamic comparator on PSP103, charge swamped by 1e6: backward Euler on a fixed 0.1 us grid
* specs/analog/decks/sar_cmp_psp_r2.cir -- reference data for specs/analog/sar_comparator_psp.t27 (analog M4b-psp, #10856, epic #10486). A netlist plus a
* .control block that prints the numbers.
* Circuit: the subcircuit dynamic_comparator of the uberWAVE golden SAR deck (wp2-parser/golden/top.spice; GPL-2.0, fetched at run time, never vendored),
* thirteen sg13_lv transistors and the inverter x1 that makes n_clkc, PSP103 (IHP-Open-PDK 21133f219b1a6da10d803e345761e77415ceff40, cornerMOSlv.lib
* mos_tt, through OSDI), at 50 C, the temperature of the golden deck. The deck reads the subcircuit text from the file named by the environment
* variable SAR_GOLDEN_SUBCKTS, the subcircuit section of the fetched deck without its .end and .global lines:
*   sed -n '/^.subckt tracking_switch/,$p' top.spice | grep -v -i -E '^\.(end|global)([[:space:]]|$)' > $SAR_GOLDEN_SUBCKTS
* ngspice reads IHP_PDK (the IHP-Open-PDK checkout), IHP_OSDI (the directory with the compiled psp103.osdi and psp103_nqs.osdi) and SAR_GOLDEN_SUBCKTS.
* Run: IHP_PDK=<checkout> IHP_OSDI=<osdi dir> SAR_GOLDEN_SUBCKTS=<file> ngspice -b sar_cmp_psp_r2.cir > sar_cmp_psp_r2.out    (ngspice-47)
* THE SCALE. PSP103 has charge: gate and junction capacitance of the thirteen devices (m up to 36, a few hundred fF on a node) which the current tables
* of the spec do not have. To compare the CURRENTS alone, the lumped node capacitances of the spec (4 fF on ap, an, dp, dn; 6 fF on net1; 2 fF on
* net2, net3, n_clkc) are multiplied by 1e6 (4 nF, 6 nF, 2 nF) and the step by the same 1e6 (0.1 ps becomes 0.1 us), so dt / C is the spec's, and the
* devices' own capacitances, a few hundred fF, are 1e-4 of the 4 nF at the largest. The currents are the real ones. Between 1e4 and 1e5 the decision
* time moved by 0.83 % and the resolution time by 1.3 %, between 1e5 and 1e6 by a tenth of that: the charge left at 1e6 is about 0.01 %.
* Inputs: VDD 1.5 V, common mode 0.75 V, VDP = 0.75 + sg h / 2^24 and VDN = 0.75 - sg h / 2^24 for h in units of 2^-24 V (the spec's words: h = 16777 is
* 2h = 33554 units = 2 mV less 0.4 uV) and sg = +1 or -1. The clock is a B source of nint(time/dt): 0 for the first 10 grid points, then a ramp of 16
* steps of 1.5/16 V, then 1.5 V. Start: from .ic and uic, ap = an = net2 = net3 = n_clkc = 1.5 V, dp = dn = 0, net1 = 0.4009999632835388 V (5872026 units, the
* spec's max(VDP, VDN) - 0.35 V rounded to a word, an initial condition and not PSP103's own rest: net1 floats and an operating point would put it at
* 0.71 V on gmin). Integration: gear with maxord 1 is backward Euler, trtol 1e7 stops the truncation test from shrinking a step; reltol 1e-7, vntol 1e-10,
* abstol 1e-12, gmin 1e-12 (at 1e-9 / 1e-12 ngspice aborts at the first clock step). 150 grid points: step j of the spec is the row of the grid point j + 10.
* What it prints, per run, after "RUN <h> <sg>": tck, the clock through 0.75 V; tfirst, the first output through 0.75 V; tres, |dp - dn| through 0.75 V
* (those two are absent when the run does not reach it); dpend and dnend, the outputs at the last point; then eight rows "<row> v(ap) v(an) v(net1) v(net2)
* v(net3) v(dp) v(dn) v(n_clkc)" at the rows 39, 59, 71, 79, 87, 95, 109, 149 (steps 20, 40, 52, 60, 68, 76, 90, 130: ngspice's opening ramp puts nine rows before the grid, so
* the row of step j is j + 19, at the time (j + 10) dt - 4 ns, which the printed time[row] shows).
.lib $IHP_PDK/ihp-sg13g2/libs.tech/ngspice/models/cornerMOSlv.lib mos_tt
.include $SAR_GOLDEN_SUBCKTS
Vdd vdd 0 1.5
Vdp vdp 0 0.75
Vdn vdn 0 0.75
Bclk clkc 0 V = 1.5*min(max(nint(time/1e-7)-10,0),16)/16
Xc vdp vdn clkc vdd 0 dp dn dynamic_comparator
Cap xc.ap 0 4n
Can xc.an 0 4n
Cn1 xc.net1 0 6n
Cn2 xc.net2 0 2n
Cn3 xc.net3 0 2n
Cdp dp 0 4n
Cdn dn 0 4n
Cnc xc.n_clkc 0 2n
Bmx mx 0 V = max(v(dp),v(dn))
Bdiff diff 0 V = abs(v(dp)-v(dn))
.ic v(xc.ap)=1.5 v(xc.an)=1.5 v(xc.net1)=0.4009999632835388 v(xc.net2)=1.5 v(xc.net3)=1.5 v(dp)=0 v(dn)=0 v(xc.n_clkc)=1.5
.temp 50
.options method=gear maxord=1 trtol=1e7 reltol=1e-7 vntol=1e-10 abstol=1e-12 gmin=1e-12 itl4=200
.control
pre_osdi $IHP_OSDI/psp103.osdi
pre_osdi $IHP_OSDI/psp103_nqs.osdi
set numdgt=10
set noprintscale
foreach h 16777 4194 1049 262 84 8 1
  foreach sg 1 -1
    alter Vdp = 0.75 + $sg * $h / 16777216
    alter Vdn = 0.75 - $sg * $h / 16777216
    tran 100n 15.5u 0 100n uic
    echo RUN $h $sg
    meas tran tck when v(clkc)=0.75 rise=1
    meas tran tfirst when v(mx)=0.75 rise=1
    meas tran tres when v(diff)=0.75 rise=1
    meas tran dpend find v(dp) at=15.5u
    meas tran dnend find v(dn) at=15.5u
    foreach r 39 59 71 79 87 95 109 149
      echo ROW $r
      print time[$r] v(xc.ap)[$r] v(xc.an)[$r] v(xc.net1)[$r] v(xc.net2)[$r] v(xc.net3)[$r] v(dp)[$r] v(dn)[$r] v(xc.n_clkc)[$r]
    end
  end
end
.endc
.end
